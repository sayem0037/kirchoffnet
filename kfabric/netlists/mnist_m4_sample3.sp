* KIRCHHOFF FOUR-QUADRANT NETWORK (KFQ) -- auto-generated
* layers [(16, 12), (12, 10)] | 1402 devices | 670 trainable sources
* Fully differential. One weight = FOUR cross-connected NMOS:
*     c+ <- (theta_a, v+) (theta_b, v-)
*     c- <- (theta_b, v+) (theta_a, v-)
* so  V(c+) - V(c-) = R k (theta_a - theta_b)(v+ - v-):  a pure
* product of a signed weight with a signed signal. Both the v^2 term
* and the per-column bias cancel IDENTICALLY. The 2-transistor version
* left a bias ~100x the signal, which saturated the neuron and pinned
* the composed map at affine R2 = 1.0000.

.MODEL NCH NMOS LEVEL=1 VTO=0.531 KP=120u LAMBDA=0.02 GAMMA=0.4 PHI=0.7
.MODEL PCH PMOS LEVEL=1 VTO=-0.71 KP=40u  LAMBDA=0.02 GAMMA=0.4 PHI=0.7

V0 vdd 0 DC 3.3

* ---- data: differential rows about vcm=1.064 V, swing=0.18 V ----
VIP1 xp1 0 DC 0.974000
VIM1 xm1 0 DC 1.154000
VIP2 xp2 0 DC 0.978500
VIM2 xm2 0 DC 1.149500
VIP3 xp3 0 DC 1.032182
VIM3 xm3 0 DC 1.095818
VIP4 xp4 0 DC 1.025429
VIM4 xm4 0 DC 1.102571
VIP5 xp5 0 DC 0.980923
VIM5 xm5 0 DC 1.147077
VIP6 xp6 0 DC 0.996890
VIM6 xm6 0 DC 1.131110
VIP7 xp7 0 DC 0.997190
VIM7 xm7 0 DC 1.130810
VIP8 xp8 0 DC 1.042400
VIM8 xm8 0 DC 1.085600
VIP9 xp9 0 DC 1.035200
VIM9 xm9 0 DC 1.092800
VIP10 xp10 0 DC 1.009077
VIM10 xm10 0 DC 1.118923
VIP11 xp11 0 DC 0.996623
VIM11 xm11 0 DC 1.131377
VIP12 xp12 0 DC 0.991561
VIM12 xm12 0 DC 1.136439
VIP13 xp13 0 DC 1.049789
VIM13 xm13 0 DC 1.078211
VIP14 xp14 0 DC 1.024769
VIM14 xm14 0 DC 1.103231
VIP15 xp15 0 DC 0.986600
VIM15 xm15 0 DC 1.141400
VIP16 xp16 0 DC 0.974000
VIM16 xm16 0 DC 1.154000

* fixed differential reference = the BIAS row. Without it
* the four-quadrant score has no constant term, the network is
* an ODD function, and any set needing a boundary that does not
* pass through the origin is unlearnable (circle: chance).
VBP bp 0 DC 1.154000
VBM bm 0 DC 0.974000

* ---- trainable weights (gate voltages) ----
VA0_0_1 g_VA0_0_1 0 DC 1.798763
VB0_0_1 g_VB0_0_1 0 DC 1.727916
VA0_1_1 g_VA0_1_1 0 DC 1.561867
VB0_1_1 g_VB0_1_1 0 DC 1.860395
VA0_2_1 g_VA0_2_1 0 DC 1.507208
VB0_2_1 g_VB0_2_1 0 DC 2.071416
VA0_3_1 g_VA0_3_1 0 DC 1.664231
VB0_3_1 g_VB0_3_1 0 DC 1.776837
VA0_4_1 g_VA0_4_1 0 DC 1.854447
VB0_4_1 g_VB0_4_1 0 DC 1.598718
VA0_5_1 g_VA0_5_1 0 DC 1.648643
VB0_5_1 g_VB0_5_1 0 DC 1.856477
VA0_6_1 g_VA0_6_1 0 DC 2.101410
VB0_6_1 g_VB0_6_1 0 DC 1.491339
VA0_7_1 g_VA0_7_1 0 DC 1.748108
VB0_7_1 g_VB0_7_1 0 DC 1.569530
VA0_8_1 g_VA0_8_1 0 DC 1.717090
VB0_8_1 g_VB0_8_1 0 DC 1.781067
VA0_9_1 g_VA0_9_1 0 DC 1.857130
VB0_9_1 g_VB0_9_1 0 DC 1.631321
VA0_10_1 g_VA0_10_1 0 DC 1.903626
VB0_10_1 g_VB0_10_1 0 DC 1.525287
VA0_11_1 g_VA0_11_1 0 DC 1.541171
VB0_11_1 g_VB0_11_1 0 DC 2.067731
VA0_12_1 g_VA0_12_1 0 DC 1.785653
VB0_12_1 g_VB0_12_1 0 DC 1.720665
VA0_13_1 g_VA0_13_1 0 DC 1.545075
VB0_13_1 g_VB0_13_1 0 DC 1.905208
VA0_14_1 g_VA0_14_1 0 DC 1.507529
VB0_14_1 g_VB0_14_1 0 DC 1.808306
VA0_15_1 g_VA0_15_1 0 DC 1.941967
VB0_15_1 g_VB0_15_1 0 DC 1.526116
VA0_16_1 g_VA0_16_1 0 DC 1.906078
VB0_16_1 g_VB0_16_1 0 DC 1.571437
VA0_0_2 g_VA0_0_2 0 DC 1.662920
VB0_0_2 g_VB0_0_2 0 DC 1.820467
VA0_1_2 g_VA0_1_2 0 DC 1.573016
VB0_1_2 g_VB0_1_2 0 DC 1.859015
VA0_2_2 g_VA0_2_2 0 DC 1.508361
VB0_2_2 g_VB0_2_2 0 DC 2.095359
VA0_3_2 g_VA0_3_2 0 DC 1.554869
VB0_3_2 g_VB0_3_2 0 DC 1.984280
VA0_4_2 g_VA0_4_2 0 DC 1.533834
VB0_4_2 g_VB0_4_2 0 DC 1.897059
VA0_5_2 g_VA0_5_2 0 DC 2.031542
VB0_5_2 g_VB0_5_2 0 DC 1.505028
VA0_6_2 g_VA0_6_2 0 DC 1.747587
VB0_6_2 g_VB0_6_2 0 DC 1.541867
VA0_7_2 g_VA0_7_2 0 DC 1.644100
VB0_7_2 g_VB0_7_2 0 DC 1.631588
VA0_8_2 g_VA0_8_2 0 DC 1.679237
VB0_8_2 g_VB0_8_2 0 DC 1.766484
VA0_9_2 g_VA0_9_2 0 DC 1.895095
VB0_9_2 g_VB0_9_2 0 DC 1.507938
VA0_10_2 g_VA0_10_2 0 DC 1.852100
VB0_10_2 g_VB0_10_2 0 DC 1.509191
VA0_11_2 g_VA0_11_2 0 DC 1.898856
VB0_11_2 g_VB0_11_2 0 DC 1.516968
VA0_12_2 g_VA0_12_2 0 DC 1.853374
VB0_12_2 g_VB0_12_2 0 DC 1.559136
VA0_13_2 g_VA0_13_2 0 DC 1.510967
VB0_13_2 g_VB0_13_2 0 DC 1.929900
VA0_14_2 g_VA0_14_2 0 DC 1.513713
VB0_14_2 g_VB0_14_2 0 DC 1.829166
VA0_15_2 g_VA0_15_2 0 DC 1.514874
VB0_15_2 g_VB0_15_2 0 DC 1.971165
VA0_16_2 g_VA0_16_2 0 DC 1.713092
VB0_16_2 g_VB0_16_2 0 DC 1.773121
VA0_0_3 g_VA0_0_3 0 DC 1.769078
VB0_0_3 g_VB0_0_3 0 DC 1.705237
VA0_1_3 g_VA0_1_3 0 DC 1.753784
VB0_1_3 g_VB0_1_3 0 DC 1.707830
VA0_2_3 g_VA0_2_3 0 DC 1.814930
VB0_2_3 g_VB0_2_3 0 DC 1.502726
VA0_3_3 g_VA0_3_3 0 DC 1.726047
VB0_3_3 g_VB0_3_3 0 DC 1.650069
VA0_4_3 g_VA0_4_3 0 DC 1.614991
VB0_4_3 g_VB0_4_3 0 DC 1.750870
VA0_5_3 g_VA0_5_3 0 DC 1.856819
VB0_5_3 g_VB0_5_3 0 DC 1.601004
VA0_6_3 g_VA0_6_3 0 DC 1.506453
VB0_6_3 g_VB0_6_3 0 DC 1.836358
VA0_7_3 g_VA0_7_3 0 DC 1.697347
VB0_7_3 g_VB0_7_3 0 DC 1.706141
VA0_8_3 g_VA0_8_3 0 DC 1.632823
VB0_8_3 g_VB0_8_3 0 DC 1.760372
VA0_9_3 g_VA0_9_3 0 DC 1.711312
VB0_9_3 g_VB0_9_3 0 DC 1.736535
VA0_10_3 g_VA0_10_3 0 DC 1.915633
VB0_10_3 g_VB0_10_3 0 DC 1.443400
VA0_11_3 g_VA0_11_3 0 DC 2.240468
VB0_11_3 g_VB0_11_3 0 DC 1.406508
VA0_12_3 g_VA0_12_3 0 DC 1.517688
VB0_12_3 g_VB0_12_3 0 DC 1.932819
VA0_13_3 g_VA0_13_3 0 DC 1.575985
VB0_13_3 g_VB0_13_3 0 DC 1.792192
VA0_14_3 g_VA0_14_3 0 DC 1.426140
VB0_14_3 g_VB0_14_3 0 DC 1.992356
VA0_15_3 g_VA0_15_3 0 DC 1.526957
VB0_15_3 g_VB0_15_3 0 DC 1.902697
VA0_16_3 g_VA0_16_3 0 DC 1.942564
VB0_16_3 g_VB0_16_3 0 DC 1.508873
VA0_0_4 g_VA0_0_4 0 DC 1.529546
VB0_0_4 g_VB0_0_4 0 DC 1.959102
VA0_1_4 g_VA0_1_4 0 DC 1.789978
VB0_1_4 g_VB0_1_4 0 DC 1.691234
VA0_2_4 g_VA0_2_4 0 DC 1.527114
VB0_2_4 g_VB0_2_4 0 DC 1.919563
VA0_3_4 g_VA0_3_4 0 DC 1.492274
VB0_3_4 g_VB0_3_4 0 DC 1.967507
VA0_4_4 g_VA0_4_4 0 DC 1.730811
VB0_4_4 g_VB0_4_4 0 DC 1.722603
VA0_5_4 g_VA0_5_4 0 DC 1.909903
VB0_5_4 g_VB0_5_4 0 DC 1.540666
VA0_6_4 g_VA0_6_4 0 DC 1.916826
VB0_6_4 g_VB0_6_4 0 DC 1.515090
VA0_7_4 g_VA0_7_4 0 DC 2.014719
VB0_7_4 g_VB0_7_4 0 DC 1.514970
VA0_8_4 g_VA0_8_4 0 DC 1.581557
VB0_8_4 g_VB0_8_4 0 DC 1.820602
VA0_9_4 g_VA0_9_4 0 DC 1.564680
VB0_9_4 g_VB0_9_4 0 DC 1.832810
VA0_10_4 g_VA0_10_4 0 DC 1.483146
VB0_10_4 g_VB0_10_4 0 DC 2.447238
VA0_11_4 g_VA0_11_4 0 DC 1.556678
VB0_11_4 g_VB0_11_4 0 DC 1.770144
VA0_12_4 g_VA0_12_4 0 DC 1.568140
VB0_12_4 g_VB0_12_4 0 DC 1.856309
VA0_13_4 g_VA0_13_4 0 DC 1.769005
VB0_13_4 g_VB0_13_4 0 DC 1.723403
VA0_14_4 g_VA0_14_4 0 DC 1.777468
VB0_14_4 g_VB0_14_4 0 DC 1.558910
VA0_15_4 g_VA0_15_4 0 DC 1.762973
VB0_15_4 g_VB0_15_4 0 DC 1.644527
VA0_16_4 g_VA0_16_4 0 DC 1.745299
VB0_16_4 g_VB0_16_4 0 DC 1.754410
VA0_0_5 g_VA0_0_5 0 DC 1.968882
VB0_0_5 g_VB0_0_5 0 DC 1.534563
VA0_1_5 g_VA0_1_5 0 DC 1.723872
VB0_1_5 g_VB0_1_5 0 DC 1.771922
VA0_2_5 g_VA0_2_5 0 DC 1.747021
VB0_2_5 g_VB0_2_5 0 DC 1.684808
VA0_3_5 g_VA0_3_5 0 DC 1.997008
VB0_3_5 g_VB0_3_5 0 DC 1.535172
VA0_4_5 g_VA0_4_5 0 DC 1.717875
VB0_4_5 g_VB0_4_5 0 DC 1.780909
VA0_5_5 g_VA0_5_5 0 DC 1.688499
VB0_5_5 g_VB0_5_5 0 DC 1.799610
VA0_6_5 g_VA0_6_5 0 DC 1.846917
VB0_6_5 g_VB0_6_5 0 DC 1.516922
VA0_7_5 g_VA0_7_5 0 DC 1.511289
VB0_7_5 g_VB0_7_5 0 DC 2.097873
VA0_8_5 g_VA0_8_5 0 DC 1.953947
VB0_8_5 g_VB0_8_5 0 DC 1.506848
VA0_9_5 g_VA0_9_5 0 DC 1.898025
VB0_9_5 g_VB0_9_5 0 DC 1.557585
VA0_10_5 g_VA0_10_5 0 DC 2.139227
VB0_10_5 g_VB0_10_5 0 DC 1.514070
VA0_11_5 g_VA0_11_5 0 DC 1.551454
VB0_11_5 g_VB0_11_5 0 DC 1.740422
VA0_12_5 g_VA0_12_5 0 DC 1.966095
VB0_12_5 g_VB0_12_5 0 DC 1.514265
VA0_13_5 g_VA0_13_5 0 DC 1.561337
VB0_13_5 g_VB0_13_5 0 DC 1.876914
VA0_14_5 g_VA0_14_5 0 DC 1.824597
VB0_14_5 g_VB0_14_5 0 DC 1.491523
VA0_15_5 g_VA0_15_5 0 DC 1.799691
VB0_15_5 g_VB0_15_5 0 DC 1.596047
VA0_16_5 g_VA0_16_5 0 DC 1.674762
VB0_16_5 g_VB0_16_5 0 DC 1.820522
VA0_0_6 g_VA0_0_6 0 DC 1.874063
VB0_0_6 g_VB0_0_6 0 DC 1.591897
VA0_1_6 g_VA0_1_6 0 DC 1.847350
VB0_1_6 g_VB0_1_6 0 DC 1.693742
VA0_2_6 g_VA0_2_6 0 DC 1.561863
VB0_2_6 g_VB0_2_6 0 DC 1.878204
VA0_3_6 g_VA0_3_6 0 DC 1.545894
VB0_3_6 g_VB0_3_6 0 DC 1.989953
VA0_4_6 g_VA0_4_6 0 DC 1.853557
VB0_4_6 g_VB0_4_6 0 DC 1.596139
VA0_5_6 g_VA0_5_6 0 DC 1.954531
VB0_5_6 g_VB0_5_6 0 DC 1.516810
VA0_6_6 g_VA0_6_6 0 DC 2.137379
VB0_6_6 g_VB0_6_6 0 DC 1.508507
VA0_7_6 g_VA0_7_6 0 DC 1.638944
VB0_7_6 g_VB0_7_6 0 DC 1.754795
VA0_8_6 g_VA0_8_6 0 DC 1.930859
VB0_8_6 g_VB0_8_6 0 DC 1.607083
VA0_9_6 g_VA0_9_6 0 DC 1.776132
VB0_9_6 g_VB0_9_6 0 DC 1.771099
VA0_10_6 g_VA0_10_6 0 DC 1.531877
VB0_10_6 g_VB0_10_6 0 DC 1.951942
VA0_11_6 g_VA0_11_6 0 DC 1.878152
VB0_11_6 g_VB0_11_6 0 DC 1.554153
VA0_12_6 g_VA0_12_6 0 DC 1.796796
VB0_12_6 g_VB0_12_6 0 DC 1.750955
VA0_13_6 g_VA0_13_6 0 DC 1.733314
VB0_13_6 g_VB0_13_6 0 DC 1.807112
VA0_14_6 g_VA0_14_6 0 DC 1.791825
VB0_14_6 g_VB0_14_6 0 DC 1.624599
VA0_15_6 g_VA0_15_6 0 DC 1.812230
VB0_15_6 g_VB0_15_6 0 DC 1.657874
VA0_16_6 g_VA0_16_6 0 DC 1.576003
VB0_16_6 g_VB0_16_6 0 DC 1.847526
VA0_0_7 g_VA0_0_7 0 DC 2.011076
VB0_0_7 g_VB0_0_7 0 DC 1.528577
VA0_1_7 g_VA0_1_7 0 DC 1.895723
VB0_1_7 g_VB0_1_7 0 DC 1.569968
VA0_2_7 g_VA0_2_7 0 DC 1.697445
VB0_2_7 g_VB0_2_7 0 DC 1.808007
VA0_3_7 g_VA0_3_7 0 DC 1.729022
VB0_3_7 g_VB0_3_7 0 DC 1.742825
VA0_4_7 g_VA0_4_7 0 DC 1.847899
VB0_4_7 g_VB0_4_7 0 DC 1.677607
VA0_5_7 g_VA0_5_7 0 DC 1.824152
VB0_5_7 g_VB0_5_7 0 DC 1.676723
VA0_6_7 g_VA0_6_7 0 DC 1.555456
VB0_6_7 g_VB0_6_7 0 DC 1.935833
VA0_7_7 g_VA0_7_7 0 DC 1.517747
VB0_7_7 g_VB0_7_7 0 DC 2.075075
VA0_8_7 g_VA0_8_7 0 DC 1.532027
VB0_8_7 g_VB0_8_7 0 DC 2.030859
VA0_9_7 g_VA0_9_7 0 DC 1.801770
VB0_9_7 g_VB0_9_7 0 DC 1.742368
VA0_10_7 g_VA0_10_7 0 DC 2.028206
VB0_10_7 g_VB0_10_7 0 DC 1.529456
VA0_11_7 g_VA0_11_7 0 DC 1.681719
VB0_11_7 g_VB0_11_7 0 DC 1.789197
VA0_12_7 g_VA0_12_7 0 DC 1.902096
VB0_12_7 g_VB0_12_7 0 DC 1.571499
VA0_13_7 g_VA0_13_7 0 DC 1.731337
VB0_13_7 g_VB0_13_7 0 DC 1.807406
VA0_14_7 g_VA0_14_7 0 DC 1.631242
VB0_14_7 g_VB0_14_7 0 DC 1.826613
VA0_15_7 g_VA0_15_7 0 DC 1.510924
VB0_15_7 g_VB0_15_7 0 DC 2.044140
VA0_16_7 g_VA0_16_7 0 DC 1.876418
VB0_16_7 g_VB0_16_7 0 DC 1.531852
VA0_0_8 g_VA0_0_8 0 DC 1.526884
VB0_0_8 g_VB0_0_8 0 DC 1.965843
VA0_1_8 g_VA0_1_8 0 DC 1.748152
VB0_1_8 g_VB0_1_8 0 DC 1.811053
VA0_2_8 g_VA0_2_8 0 DC 1.712373
VB0_2_8 g_VB0_2_8 0 DC 1.802420
VA0_3_8 g_VA0_3_8 0 DC 1.735613
VB0_3_8 g_VB0_3_8 0 DC 1.738338
VA0_4_8 g_VA0_4_8 0 DC 1.943840
VB0_4_8 g_VB0_4_8 0 DC 1.544017
VA0_5_8 g_VA0_5_8 0 DC 1.764934
VB0_5_8 g_VB0_5_8 0 DC 1.788819
VA0_6_8 g_VA0_6_8 0 DC 1.728799
VB0_6_8 g_VB0_6_8 0 DC 1.782344
VA0_7_8 g_VA0_7_8 0 DC 1.510817
VB0_7_8 g_VB0_7_8 0 DC 2.265266
VA0_8_8 g_VA0_8_8 0 DC 1.553002
VB0_8_8 g_VB0_8_8 0 DC 1.904518
VA0_9_8 g_VA0_9_8 0 DC 1.505810
VB0_9_8 g_VB0_9_8 0 DC 2.094682
VA0_10_8 g_VA0_10_8 0 DC 2.315872
VB0_10_8 g_VB0_10_8 0 DC 1.516961
VA0_11_8 g_VA0_11_8 0 DC 1.870648
VB0_11_8 g_VB0_11_8 0 DC 1.577592
VA0_12_8 g_VA0_12_8 0 DC 1.627975
VB0_12_8 g_VB0_12_8 0 DC 1.897882
VA0_13_8 g_VA0_13_8 0 DC 1.753299
VB0_13_8 g_VB0_13_8 0 DC 1.786237
VA0_14_8 g_VA0_14_8 0 DC 1.556758
VB0_14_8 g_VB0_14_8 0 DC 1.912586
VA0_15_8 g_VA0_15_8 0 DC 1.667692
VB0_15_8 g_VB0_15_8 0 DC 1.810365
VA0_16_8 g_VA0_16_8 0 DC 1.815910
VB0_16_8 g_VB0_16_8 0 DC 1.745527
VA0_0_9 g_VA0_0_9 0 DC 2.034105
VB0_0_9 g_VB0_0_9 0 DC 1.505107
VA0_1_9 g_VA0_1_9 0 DC 1.863117
VB0_1_9 g_VB0_1_9 0 DC 1.625247
VA0_2_9 g_VA0_2_9 0 DC 1.951503
VB0_2_9 g_VB0_2_9 0 DC 1.524680
VA0_3_9 g_VA0_3_9 0 DC 1.889402
VB0_3_9 g_VB0_3_9 0 DC 1.569441
VA0_4_9 g_VA0_4_9 0 DC 1.673787
VB0_4_9 g_VB0_4_9 0 DC 1.822500
VA0_5_9 g_VA0_5_9 0 DC 1.690458
VB0_5_9 g_VB0_5_9 0 DC 1.809527
VA0_6_9 g_VA0_6_9 0 DC 1.829897
VB0_6_9 g_VB0_6_9 0 DC 1.523548
VA0_7_9 g_VA0_7_9 0 DC 1.868087
VB0_7_9 g_VB0_7_9 0 DC 1.513039
VA0_8_9 g_VA0_8_9 0 DC 1.516753
VB0_8_9 g_VB0_8_9 0 DC 2.102560
VA0_9_9 g_VA0_9_9 0 DC 2.001593
VB0_9_9 g_VB0_9_9 0 DC 1.504269
VA0_10_9 g_VA0_10_9 0 DC 1.506164
VB0_10_9 g_VB0_10_9 0 DC 2.070558
VA0_11_9 g_VA0_11_9 0 DC 1.649229
VB0_11_9 g_VB0_11_9 0 DC 1.736942
VA0_12_9 g_VA0_12_9 0 DC 1.866305
VB0_12_9 g_VB0_12_9 0 DC 1.608651
VA0_13_9 g_VA0_13_9 0 DC 1.935635
VB0_13_9 g_VB0_13_9 0 DC 1.499672
VA0_14_9 g_VA0_14_9 0 DC 1.736144
VB0_14_9 g_VB0_14_9 0 DC 1.701324
VA0_15_9 g_VA0_15_9 0 DC 1.719140
VB0_15_9 g_VB0_15_9 0 DC 1.730260
VA0_16_9 g_VA0_16_9 0 DC 1.765277
VB0_16_9 g_VB0_16_9 0 DC 1.746050
VA0_0_10 g_VA0_0_10 0 DC 1.756024
VB0_0_10 g_VB0_0_10 0 DC 1.786559
VA0_1_10 g_VA0_1_10 0 DC 1.826621
VB0_1_10 g_VB0_1_10 0 DC 1.701465
VA0_2_10 g_VA0_2_10 0 DC 1.555847
VB0_2_10 g_VB0_2_10 0 DC 1.836915
VA0_3_10 g_VA0_3_10 0 DC 1.732389
VB0_3_10 g_VB0_3_10 0 DC 1.747227
VA0_4_10 g_VA0_4_10 0 DC 1.911154
VB0_4_10 g_VB0_4_10 0 DC 1.608772
VA0_5_10 g_VA0_5_10 0 DC 1.913407
VB0_5_10 g_VB0_5_10 0 DC 1.550916
VA0_6_10 g_VA0_6_10 0 DC 1.934456
VB0_6_10 g_VB0_6_10 0 DC 1.513664
VA0_7_10 g_VA0_7_10 0 DC 1.511568
VB0_7_10 g_VB0_7_10 0 DC 2.127388
VA0_8_10 g_VA0_8_10 0 DC 1.745430
VB0_8_10 g_VB0_8_10 0 DC 1.773899
VA0_9_10 g_VA0_9_10 0 DC 1.567871
VB0_9_10 g_VB0_9_10 0 DC 1.907679
VA0_10_10 g_VA0_10_10 0 DC 1.535454
VB0_10_10 g_VB0_10_10 0 DC 1.868927
VA0_11_10 g_VA0_11_10 0 DC 1.956101
VB0_11_10 g_VB0_11_10 0 DC 1.552786
VA0_12_10 g_VA0_12_10 0 DC 1.714829
VB0_12_10 g_VB0_12_10 0 DC 1.813832
VA0_13_10 g_VA0_13_10 0 DC 1.760655
VB0_13_10 g_VB0_13_10 0 DC 1.772874
VA0_14_10 g_VA0_14_10 0 DC 1.857142
VB0_14_10 g_VB0_14_10 0 DC 1.531984
VA0_15_10 g_VA0_15_10 0 DC 1.677121
VB0_15_10 g_VB0_15_10 0 DC 1.783314
VA0_16_10 g_VA0_16_10 0 DC 1.714136
VB0_16_10 g_VB0_16_10 0 DC 1.816078
VA0_0_11 g_VA0_0_11 0 DC 1.618806
VB0_0_11 g_VB0_0_11 0 DC 1.904970
VA0_1_11 g_VA0_1_11 0 DC 1.766507
VB0_1_11 g_VB0_1_11 0 DC 1.782966
VA0_2_11 g_VA0_2_11 0 DC 1.739112
VB0_2_11 g_VB0_2_11 0 DC 1.782458
VA0_3_11 g_VA0_3_11 0 DC 1.572754
VB0_3_11 g_VB0_3_11 0 DC 1.870284
VA0_4_11 g_VA0_4_11 0 DC 1.579727
VB0_4_11 g_VB0_4_11 0 DC 1.907821
VA0_5_11 g_VA0_5_11 0 DC 1.950617
VB0_5_11 g_VB0_5_11 0 DC 1.556167
VA0_6_11 g_VA0_6_11 0 DC 1.572968
VB0_6_11 g_VB0_6_11 0 DC 1.815111
VA0_7_11 g_VA0_7_11 0 DC 2.581947
VB0_7_11 g_VB0_7_11 0 DC 1.514251
VA0_8_11 g_VA0_8_11 0 DC 2.072713
VB0_8_11 g_VB0_8_11 0 DC 1.522096
VA0_9_11 g_VA0_9_11 0 DC 1.725005
VB0_9_11 g_VB0_9_11 0 DC 1.823593
VA0_10_11 g_VA0_10_11 0 DC 1.768923
VB0_10_11 g_VB0_10_11 0 DC 1.703461
VA0_11_11 g_VA0_11_11 0 DC 1.810389
VB0_11_11 g_VB0_11_11 0 DC 1.662311
VA0_12_11 g_VA0_12_11 0 DC 1.510961
VB0_12_11 g_VB0_12_11 0 DC 2.059467
VA0_13_11 g_VA0_13_11 0 DC 1.736007
VB0_13_11 g_VB0_13_11 0 DC 1.811277
VA0_14_11 g_VA0_14_11 0 DC 1.603070
VB0_14_11 g_VB0_14_11 0 DC 1.839892
VA0_15_11 g_VA0_15_11 0 DC 1.668688
VB0_15_11 g_VB0_15_11 0 DC 1.830511
VA0_16_11 g_VA0_16_11 0 DC 1.777605
VB0_16_11 g_VB0_16_11 0 DC 1.737672
VA0_0_12 g_VA0_0_12 0 DC 1.893546
VB0_0_12 g_VB0_0_12 0 DC 1.582668
VA0_1_12 g_VA0_1_12 0 DC 1.873402
VB0_1_12 g_VB0_1_12 0 DC 1.671551
VA0_2_12 g_VA0_2_12 0 DC 1.931028
VB0_2_12 g_VB0_2_12 0 DC 1.535487
VA0_3_12 g_VA0_3_12 0 DC 1.616952
VB0_3_12 g_VB0_3_12 0 DC 1.898501
VA0_4_12 g_VA0_4_12 0 DC 1.686897
VB0_4_12 g_VB0_4_12 0 DC 1.869317
VA0_5_12 g_VA0_5_12 0 DC 1.921059
VB0_5_12 g_VB0_5_12 0 DC 1.560896
VA0_6_12 g_VA0_6_12 0 DC 1.514413
VB0_6_12 g_VB0_6_12 0 DC 2.119532
VA0_7_12 g_VA0_7_12 0 DC 2.111999
VB0_7_12 g_VB0_7_12 0 DC 1.520657
VA0_8_12 g_VA0_8_12 0 DC 1.891891
VB0_8_12 g_VB0_8_12 0 DC 1.563868
VA0_9_12 g_VA0_9_12 0 DC 1.839691
VB0_9_12 g_VB0_9_12 0 DC 1.727428
VA0_10_12 g_VA0_10_12 0 DC 1.511777
VB0_10_12 g_VB0_10_12 0 DC 2.260993
VA0_11_12 g_VA0_11_12 0 DC 1.732562
VB0_11_12 g_VB0_11_12 0 DC 1.792127
VA0_12_12 g_VA0_12_12 0 DC 1.927327
VB0_12_12 g_VB0_12_12 0 DC 1.600568
VA0_13_12 g_VA0_13_12 0 DC 1.857536
VB0_13_12 g_VB0_13_12 0 DC 1.711405
VA0_14_12 g_VA0_14_12 0 DC 1.892780
VB0_14_12 g_VB0_14_12 0 DC 1.569554
VA0_15_12 g_VA0_15_12 0 DC 1.744544
VB0_15_12 g_VB0_15_12 0 DC 1.774451
VA0_16_12 g_VA0_16_12 0 DC 1.552693
VB0_16_12 g_VB0_16_12 0 DC 1.921913
VA1_0_1 g_VA1_0_1 0 DC 3.004982
VB1_0_1 g_VB1_0_1 0 DC 2.819018
VA1_1_1 g_VA1_1_1 0 DC 3.159781
VB1_1_1 g_VB1_1_1 0 DC 2.796429
VA1_2_1 g_VA1_2_1 0 DC 2.829474
VB1_2_1 g_VB1_2_1 0 DC 2.659812
VA1_3_1 g_VA1_3_1 0 DC 2.733692
VB1_3_1 g_VB1_3_1 0 DC 3.199094
VA1_4_1 g_VA1_4_1 0 DC 2.802459
VB1_4_1 g_VB1_4_1 0 DC 3.019550
VA1_5_1 g_VA1_5_1 0 DC 3.177740
VB1_5_1 g_VB1_5_1 0 DC 2.701155
VA1_6_1 g_VA1_6_1 0 DC 2.905906
VB1_6_1 g_VB1_6_1 0 DC 3.041118
VA1_7_1 g_VA1_7_1 0 DC 2.981155
VB1_7_1 g_VB1_7_1 0 DC 3.038831
VA1_8_1 g_VA1_8_1 0 DC 2.737242
VB1_8_1 g_VB1_8_1 0 DC 3.197067
VA1_9_1 g_VA1_9_1 0 DC 2.892266
VB1_9_1 g_VB1_9_1 0 DC 2.799379
VA1_10_1 g_VA1_10_1 0 DC 2.813985
VB1_10_1 g_VB1_10_1 0 DC 3.066773
VA1_11_1 g_VA1_11_1 0 DC 2.850315
VB1_11_1 g_VB1_11_1 0 DC 3.054369
VA1_12_1 g_VA1_12_1 0 DC 3.029258
VB1_12_1 g_VB1_12_1 0 DC 3.031448
VA1_0_2 g_VA1_0_2 0 DC 2.960851
VB1_0_2 g_VB1_0_2 0 DC 2.863149
VA1_1_2 g_VA1_1_2 0 DC 2.836700
VB1_1_2 g_VB1_1_2 0 DC 2.858338
VA1_2_2 g_VA1_2_2 0 DC 2.861137
VB1_2_2 g_VB1_2_2 0 DC 2.790034
VA1_3_2 g_VA1_3_2 0 DC 2.807876
VB1_3_2 g_VB1_3_2 0 DC 2.805620
VA1_4_2 g_VA1_4_2 0 DC 2.843531
VB1_4_2 g_VB1_4_2 0 DC 2.807974
VA1_5_2 g_VA1_5_2 0 DC 2.738590
VB1_5_2 g_VB1_5_2 0 DC 3.018744
VA1_6_2 g_VA1_6_2 0 DC 2.783366
VB1_6_2 g_VB1_6_2 0 DC 2.997734
VA1_7_2 g_VA1_7_2 0 DC 3.013870
VB1_7_2 g_VB1_7_2 0 DC 2.722630
VA1_8_2 g_VA1_8_2 0 DC 3.040945
VB1_8_2 g_VB1_8_2 0 DC 2.779152
VA1_9_2 g_VA1_9_2 0 DC 2.831936
VB1_9_2 g_VB1_9_2 0 DC 2.797547
VA1_10_2 g_VA1_10_2 0 DC 2.714422
VB1_10_2 g_VB1_10_2 0 DC 3.049940
VA1_11_2 g_VA1_11_2 0 DC 2.930455
VB1_11_2 g_VB1_11_2 0 DC 2.879998
VA1_12_2 g_VA1_12_2 0 DC 2.882972
VB1_12_2 g_VB1_12_2 0 DC 2.883658
VA1_0_3 g_VA1_0_3 0 DC 2.992254
VB1_0_3 g_VB1_0_3 0 DC 2.831746
VA1_1_3 g_VA1_1_3 0 DC 2.750504
VB1_1_3 g_VB1_1_3 0 DC 3.109549
VA1_2_3 g_VA1_2_3 0 DC 2.848876
VB1_2_3 g_VB1_2_3 0 DC 2.754419
VA1_3_3 g_VA1_3_3 0 DC 3.200000
VB1_3_3 g_VB1_3_3 0 DC 2.685587
VA1_4_3 g_VA1_4_3 0 DC 2.744670
VB1_4_3 g_VB1_4_3 0 DC 3.194407
VA1_5_3 g_VA1_5_3 0 DC 2.888539
VB1_5_3 g_VB1_5_3 0 DC 2.830083
VA1_6_3 g_VA1_6_3 0 DC 2.937016
VB1_6_3 g_VB1_6_3 0 DC 2.994766
VA1_7_3 g_VA1_7_3 0 DC 3.051763
VB1_7_3 g_VB1_7_3 0 DC 2.711875
VA1_8_3 g_VA1_8_3 0 DC 2.860272
VB1_8_3 g_VB1_8_3 0 DC 3.008098
VA1_9_3 g_VA1_9_3 0 DC 3.196031
VB1_9_3 g_VB1_9_3 0 DC 2.664927
VA1_10_3 g_VA1_10_3 0 DC 2.762064
VB1_10_3 g_VB1_10_3 0 DC 2.996343
VA1_11_3 g_VA1_11_3 0 DC 2.954874
VB1_11_3 g_VB1_11_3 0 DC 2.750725
VA1_12_3 g_VA1_12_3 0 DC 2.962840
VB1_12_3 g_VB1_12_3 0 DC 2.906782
VA1_0_4 g_VA1_0_4 0 DC 2.920875
VB1_0_4 g_VB1_0_4 0 DC 2.903125
VA1_1_4 g_VA1_1_4 0 DC 2.734253
VB1_1_4 g_VB1_1_4 0 DC 3.034140
VA1_2_4 g_VA1_2_4 0 DC 2.753059
VB1_2_4 g_VB1_2_4 0 DC 3.197705
VA1_3_4 g_VA1_3_4 0 DC 2.796753
VB1_3_4 g_VB1_3_4 0 DC 2.878707
VA1_4_4 g_VA1_4_4 0 DC 2.935530
VB1_4_4 g_VB1_4_4 0 DC 2.722039
VA1_5_4 g_VA1_5_4 0 DC 2.775162
VB1_5_4 g_VB1_5_4 0 DC 3.087591
VA1_6_4 g_VA1_6_4 0 DC 2.790493
VB1_6_4 g_VB1_6_4 0 DC 2.958791
VA1_7_4 g_VA1_7_4 0 DC 2.760655
VB1_7_4 g_VB1_7_4 0 DC 3.086775
VA1_8_4 g_VA1_8_4 0 DC 2.775588
VB1_8_4 g_VB1_8_4 0 DC 3.088012
VA1_9_4 g_VA1_9_4 0 DC 3.150256
VB1_9_4 g_VB1_9_4 0 DC 2.663539
VA1_10_4 g_VA1_10_4 0 DC 2.920080
VB1_10_4 g_VB1_10_4 0 DC 3.018631
VA1_11_4 g_VA1_11_4 0 DC 2.901244
VB1_11_4 g_VB1_11_4 0 DC 2.877882
VA1_12_4 g_VA1_12_4 0 DC 3.113015
VB1_12_4 g_VB1_12_4 0 DC 2.812725
VA1_0_5 g_VA1_0_5 0 DC 2.873011
VB1_0_5 g_VB1_0_5 0 DC 2.950989
VA1_1_5 g_VA1_1_5 0 DC 3.128191
VB1_1_5 g_VB1_1_5 0 DC 2.786297
VA1_2_5 g_VA1_2_5 0 DC 3.183673
VB1_2_5 g_VB1_2_5 0 DC 2.699484
VA1_3_5 g_VA1_3_5 0 DC 3.051141
VB1_3_5 g_VB1_3_5 0 DC 2.758487
VA1_4_5 g_VA1_4_5 0 DC 2.819880
VB1_4_5 g_VB1_4_5 0 DC 2.822820
VA1_5_5 g_VA1_5_5 0 DC 2.797934
VB1_5_5 g_VB1_5_5 0 DC 2.889985
VA1_6_5 g_VA1_6_5 0 DC 3.020610
VB1_6_5 g_VB1_6_5 0 DC 2.739134
VA1_7_5 g_VA1_7_5 0 DC 3.047656
VB1_7_5 g_VB1_7_5 0 DC 2.938299
VA1_8_5 g_VA1_8_5 0 DC 3.116920
VB1_8_5 g_VB1_8_5 0 DC 2.806610
VA1_9_5 g_VA1_9_5 0 DC 2.785660
VB1_9_5 g_VB1_9_5 0 DC 3.173523
VA1_10_5 g_VA1_10_5 0 DC 2.927231
VB1_10_5 g_VB1_10_5 0 DC 3.057979
VA1_11_5 g_VA1_11_5 0 DC 3.045648
VB1_11_5 g_VB1_11_5 0 DC 2.826220
VA1_12_5 g_VA1_12_5 0 DC 2.765565
VB1_12_5 g_VB1_12_5 0 DC 3.041590
VA1_0_6 g_VA1_0_6 0 DC 3.031829
VB1_0_6 g_VB1_0_6 0 DC 2.792171
VA1_1_6 g_VA1_1_6 0 DC 3.198539
VB1_1_6 g_VB1_1_6 0 DC 2.703193
VA1_2_6 g_VA1_2_6 0 DC 2.832731
VB1_2_6 g_VB1_2_6 0 DC 3.130200
VA1_3_6 g_VA1_3_6 0 DC 2.738763
VB1_3_6 g_VB1_3_6 0 DC 2.958689
VA1_4_6 g_VA1_4_6 0 DC 2.807841
VB1_4_6 g_VB1_4_6 0 DC 2.759224
VA1_5_6 g_VA1_5_6 0 DC 2.979831
VB1_5_6 g_VB1_5_6 0 DC 2.803658
VA1_6_6 g_VA1_6_6 0 DC 2.961518
VB1_6_6 g_VB1_6_6 0 DC 2.771586
VA1_7_6 g_VA1_7_6 0 DC 2.986194
VB1_7_6 g_VB1_7_6 0 DC 2.836098
VA1_8_6 g_VA1_8_6 0 DC 2.809023
VB1_8_6 g_VB1_8_6 0 DC 2.855043
VA1_9_6 g_VA1_9_6 0 DC 3.142988
VB1_9_6 g_VB1_9_6 0 DC 2.667264
VA1_10_6 g_VA1_10_6 0 DC 3.020447
VB1_10_6 g_VB1_10_6 0 DC 2.668746
VA1_11_6 g_VA1_11_6 0 DC 2.780211
VB1_11_6 g_VB1_11_6 0 DC 3.198020
VA1_12_6 g_VA1_12_6 0 DC 2.840650
VB1_12_6 g_VB1_12_6 0 DC 3.132955
VA1_0_7 g_VA1_0_7 0 DC 2.925276
VB1_0_7 g_VB1_0_7 0 DC 2.898724
VA1_1_7 g_VA1_1_7 0 DC 2.852010
VB1_1_7 g_VB1_1_7 0 DC 3.108140
VA1_2_7 g_VA1_2_7 0 DC 3.005232
VB1_2_7 g_VB1_2_7 0 DC 2.716843
VA1_3_7 g_VA1_3_7 0 DC 3.081500
VB1_3_7 g_VB1_3_7 0 DC 2.763543
VA1_4_7 g_VA1_4_7 0 DC 2.686030
VB1_4_7 g_VB1_4_7 0 DC 3.193757
VA1_5_7 g_VA1_5_7 0 DC 3.171057
VB1_5_7 g_VB1_5_7 0 DC 2.772662
VA1_6_7 g_VA1_6_7 0 DC 2.923752
VB1_6_7 g_VB1_6_7 0 DC 2.993382
VA1_7_7 g_VA1_7_7 0 DC 3.083507
VB1_7_7 g_VB1_7_7 0 DC 2.834143
VA1_8_7 g_VA1_8_7 0 DC 3.194290
VB1_8_7 g_VB1_8_7 0 DC 2.683763
VA1_9_7 g_VA1_9_7 0 DC 2.674059
VB1_9_7 g_VB1_9_7 0 DC 3.029486
VA1_10_7 g_VA1_10_7 0 DC 3.048325
VB1_10_7 g_VB1_10_7 0 DC 2.803958
VA1_11_7 g_VA1_11_7 0 DC 2.799582
VB1_11_7 g_VB1_11_7 0 DC 3.183252
VA1_12_7 g_VA1_12_7 0 DC 2.796421
VB1_12_7 g_VB1_12_7 0 DC 3.132476
VA1_0_8 g_VA1_0_8 0 DC 2.816418
VB1_0_8 g_VB1_0_8 0 DC 3.007582
VA1_1_8 g_VA1_1_8 0 DC 2.823981
VB1_1_8 g_VB1_1_8 0 DC 3.152795
VA1_2_8 g_VA1_2_8 0 DC 2.834709
VB1_2_8 g_VB1_2_8 0 DC 2.721668
VA1_3_8 g_VA1_3_8 0 DC 2.801411
VB1_3_8 g_VB1_3_8 0 DC 2.811569
VA1_4_8 g_VA1_4_8 0 DC 3.190356
VB1_4_8 g_VB1_4_8 0 DC 2.728163
VA1_5_8 g_VA1_5_8 0 DC 2.779005
VB1_5_8 g_VB1_5_8 0 DC 3.170754
VA1_6_8 g_VA1_6_8 0 DC 3.125086
VB1_6_8 g_VB1_6_8 0 DC 2.783625
VA1_7_8 g_VA1_7_8 0 DC 2.823161
VB1_7_8 g_VB1_7_8 0 DC 2.981851
VA1_8_8 g_VA1_8_8 0 DC 2.746435
VB1_8_8 g_VB1_8_8 0 DC 3.019538
VA1_9_8 g_VA1_9_8 0 DC 2.824364
VB1_9_8 g_VB1_9_8 0 DC 2.881096
VA1_10_8 g_VA1_10_8 0 DC 3.120787
VB1_10_8 g_VB1_10_8 0 DC 2.753113
VA1_11_8 g_VA1_11_8 0 DC 3.146009
VB1_11_8 g_VB1_11_8 0 DC 2.803482
VA1_12_8 g_VA1_12_8 0 DC 3.139759
VB1_12_8 g_VB1_12_8 0 DC 2.757450
VA1_0_9 g_VA1_0_9 0 DC 2.999276
VB1_0_9 g_VB1_0_9 0 DC 2.824724
VA1_1_9 g_VA1_1_9 0 DC 2.841650
VB1_1_9 g_VB1_1_9 0 DC 2.796536
VA1_2_9 g_VA1_2_9 0 DC 2.742088
VB1_2_9 g_VB1_2_9 0 DC 3.200000
VA1_3_9 g_VA1_3_9 0 DC 2.792370
VB1_3_9 g_VB1_3_9 0 DC 2.820085
VA1_4_9 g_VA1_4_9 0 DC 2.777378
VB1_4_9 g_VB1_4_9 0 DC 3.018155
VA1_5_9 g_VA1_5_9 0 DC 3.037425
VB1_5_9 g_VB1_5_9 0 DC 2.817346
VA1_6_9 g_VA1_6_9 0 DC 2.971898
VB1_6_9 g_VB1_6_9 0 DC 2.985506
VA1_7_9 g_VA1_7_9 0 DC 2.618803
VB1_7_9 g_VB1_7_9 0 DC 3.099546
VA1_8_9 g_VA1_8_9 0 DC 2.888988
VB1_8_9 g_VB1_8_9 0 DC 2.765872
VA1_9_9 g_VA1_9_9 0 DC 2.621491
VB1_9_9 g_VB1_9_9 0 DC 3.104947
VA1_10_9 g_VA1_10_9 0 DC 2.943486
VB1_10_9 g_VB1_10_9 0 DC 3.021227
VA1_11_9 g_VA1_11_9 0 DC 3.039416
VB1_11_9 g_VB1_11_9 0 DC 2.648003
VA1_12_9 g_VA1_12_9 0 DC 2.912312
VB1_12_9 g_VB1_12_9 0 DC 3.100917
VA1_0_10 g_VA1_0_10 0 DC 2.950689
VB1_0_10 g_VB1_0_10 0 DC 2.873311
VA1_1_10 g_VA1_1_10 0 DC 3.038218
VB1_1_10 g_VB1_1_10 0 DC 2.803337
VA1_2_10 g_VA1_2_10 0 DC 3.051049
VB1_2_10 g_VB1_2_10 0 DC 2.797335
VA1_3_10 g_VA1_3_10 0 DC 2.949309
VB1_3_10 g_VB1_3_10 0 DC 2.824889
VA1_4_10 g_VA1_4_10 0 DC 3.042108
VB1_4_10 g_VB1_4_10 0 DC 2.744832
VA1_5_10 g_VA1_5_10 0 DC 2.738531
VB1_5_10 g_VB1_5_10 0 DC 2.946798
VA1_6_10 g_VA1_6_10 0 DC 2.964844
VB1_6_10 g_VB1_6_10 0 DC 2.920515
VA1_7_10 g_VA1_7_10 0 DC 2.829202
VB1_7_10 g_VB1_7_10 0 DC 2.965598
VA1_8_10 g_VA1_8_10 0 DC 2.879838
VB1_8_10 g_VB1_8_10 0 DC 2.868383
VA1_9_10 g_VA1_9_10 0 DC 2.832023
VB1_9_10 g_VB1_9_10 0 DC 2.646628
VA1_10_10 g_VA1_10_10 0 DC 2.920368
VB1_10_10 g_VB1_10_10 0 DC 2.884489
VA1_11_10 g_VA1_11_10 0 DC 3.080135
VB1_11_10 g_VB1_11_10 0 DC 2.772325
VA1_12_10 g_VA1_12_10 0 DC 2.636702
VB1_12_10 g_VB1_12_10 0 DC 2.725756

* ---- trainable per-layer gain (diff-pair tail bias) ----
VT0 g_VT0 0 DC 1.500000
VT1 g_VT1 0 DC 1.500000

* ===== layer 0: 16 -> 12 (four-quadrant) =====
* column pair cp0_1/cn0_1: 16 four-quadrant synapses + bias row
MVA0_0_1P cp0_1 g_VA0_0_1 bp 0 NCH L=1u W=4u
MVB0_0_1P cp0_1 g_VB0_0_1 bm 0 NCH L=1u W=4u
MVB0_0_1N cn0_1 g_VB0_0_1 bp 0 NCH L=1u W=4u
MVA0_0_1N cn0_1 g_VA0_0_1 bm 0 NCH L=1u W=4u
MVA0_1_1P cp0_1 g_VA0_1_1 xp1 0 NCH L=1u W=4u
MVB0_1_1P cp0_1 g_VB0_1_1 xm1 0 NCH L=1u W=4u
MVB0_1_1N cn0_1 g_VB0_1_1 xp1 0 NCH L=1u W=4u
MVA0_1_1N cn0_1 g_VA0_1_1 xm1 0 NCH L=1u W=4u
MVA0_2_1P cp0_1 g_VA0_2_1 xp2 0 NCH L=1u W=4u
MVB0_2_1P cp0_1 g_VB0_2_1 xm2 0 NCH L=1u W=4u
MVB0_2_1N cn0_1 g_VB0_2_1 xp2 0 NCH L=1u W=4u
MVA0_2_1N cn0_1 g_VA0_2_1 xm2 0 NCH L=1u W=4u
MVA0_3_1P cp0_1 g_VA0_3_1 xp3 0 NCH L=1u W=4u
MVB0_3_1P cp0_1 g_VB0_3_1 xm3 0 NCH L=1u W=4u
MVB0_3_1N cn0_1 g_VB0_3_1 xp3 0 NCH L=1u W=4u
MVA0_3_1N cn0_1 g_VA0_3_1 xm3 0 NCH L=1u W=4u
MVA0_4_1P cp0_1 g_VA0_4_1 xp4 0 NCH L=1u W=4u
MVB0_4_1P cp0_1 g_VB0_4_1 xm4 0 NCH L=1u W=4u
MVB0_4_1N cn0_1 g_VB0_4_1 xp4 0 NCH L=1u W=4u
MVA0_4_1N cn0_1 g_VA0_4_1 xm4 0 NCH L=1u W=4u
MVA0_5_1P cp0_1 g_VA0_5_1 xp5 0 NCH L=1u W=4u
MVB0_5_1P cp0_1 g_VB0_5_1 xm5 0 NCH L=1u W=4u
MVB0_5_1N cn0_1 g_VB0_5_1 xp5 0 NCH L=1u W=4u
MVA0_5_1N cn0_1 g_VA0_5_1 xm5 0 NCH L=1u W=4u
MVA0_6_1P cp0_1 g_VA0_6_1 xp6 0 NCH L=1u W=4u
MVB0_6_1P cp0_1 g_VB0_6_1 xm6 0 NCH L=1u W=4u
MVB0_6_1N cn0_1 g_VB0_6_1 xp6 0 NCH L=1u W=4u
MVA0_6_1N cn0_1 g_VA0_6_1 xm6 0 NCH L=1u W=4u
MVA0_7_1P cp0_1 g_VA0_7_1 xp7 0 NCH L=1u W=4u
MVB0_7_1P cp0_1 g_VB0_7_1 xm7 0 NCH L=1u W=4u
MVB0_7_1N cn0_1 g_VB0_7_1 xp7 0 NCH L=1u W=4u
MVA0_7_1N cn0_1 g_VA0_7_1 xm7 0 NCH L=1u W=4u
MVA0_8_1P cp0_1 g_VA0_8_1 xp8 0 NCH L=1u W=4u
MVB0_8_1P cp0_1 g_VB0_8_1 xm8 0 NCH L=1u W=4u
MVB0_8_1N cn0_1 g_VB0_8_1 xp8 0 NCH L=1u W=4u
MVA0_8_1N cn0_1 g_VA0_8_1 xm8 0 NCH L=1u W=4u
MVA0_9_1P cp0_1 g_VA0_9_1 xp9 0 NCH L=1u W=4u
MVB0_9_1P cp0_1 g_VB0_9_1 xm9 0 NCH L=1u W=4u
MVB0_9_1N cn0_1 g_VB0_9_1 xp9 0 NCH L=1u W=4u
MVA0_9_1N cn0_1 g_VA0_9_1 xm9 0 NCH L=1u W=4u
MVA0_10_1P cp0_1 g_VA0_10_1 xp10 0 NCH L=1u W=4u
MVB0_10_1P cp0_1 g_VB0_10_1 xm10 0 NCH L=1u W=4u
MVB0_10_1N cn0_1 g_VB0_10_1 xp10 0 NCH L=1u W=4u
MVA0_10_1N cn0_1 g_VA0_10_1 xm10 0 NCH L=1u W=4u
MVA0_11_1P cp0_1 g_VA0_11_1 xp11 0 NCH L=1u W=4u
MVB0_11_1P cp0_1 g_VB0_11_1 xm11 0 NCH L=1u W=4u
MVB0_11_1N cn0_1 g_VB0_11_1 xp11 0 NCH L=1u W=4u
MVA0_11_1N cn0_1 g_VA0_11_1 xm11 0 NCH L=1u W=4u
MVA0_12_1P cp0_1 g_VA0_12_1 xp12 0 NCH L=1u W=4u
MVB0_12_1P cp0_1 g_VB0_12_1 xm12 0 NCH L=1u W=4u
MVB0_12_1N cn0_1 g_VB0_12_1 xp12 0 NCH L=1u W=4u
MVA0_12_1N cn0_1 g_VA0_12_1 xm12 0 NCH L=1u W=4u
MVA0_13_1P cp0_1 g_VA0_13_1 xp13 0 NCH L=1u W=4u
MVB0_13_1P cp0_1 g_VB0_13_1 xm13 0 NCH L=1u W=4u
MVB0_13_1N cn0_1 g_VB0_13_1 xp13 0 NCH L=1u W=4u
MVA0_13_1N cn0_1 g_VA0_13_1 xm13 0 NCH L=1u W=4u
MVA0_14_1P cp0_1 g_VA0_14_1 xp14 0 NCH L=1u W=4u
MVB0_14_1P cp0_1 g_VB0_14_1 xm14 0 NCH L=1u W=4u
MVB0_14_1N cn0_1 g_VB0_14_1 xp14 0 NCH L=1u W=4u
MVA0_14_1N cn0_1 g_VA0_14_1 xm14 0 NCH L=1u W=4u
MVA0_15_1P cp0_1 g_VA0_15_1 xp15 0 NCH L=1u W=4u
MVB0_15_1P cp0_1 g_VB0_15_1 xm15 0 NCH L=1u W=4u
MVB0_15_1N cn0_1 g_VB0_15_1 xp15 0 NCH L=1u W=4u
MVA0_15_1N cn0_1 g_VA0_15_1 xm15 0 NCH L=1u W=4u
MVA0_16_1P cp0_1 g_VA0_16_1 xp16 0 NCH L=1u W=4u
MVB0_16_1P cp0_1 g_VB0_16_1 xm16 0 NCH L=1u W=4u
MVB0_16_1N cn0_1 g_VB0_16_1 xp16 0 NCH L=1u W=4u
MVA0_16_1N cn0_1 g_VA0_16_1 xm16 0 NCH L=1u W=4u
RLP0_1 vdd cp0_1 3660
RLN0_1 vdd cn0_1 3660
CCP0_1 cp0_1 0 0.1f
CCN0_1 cn0_1 0 0.1f
MDP0_1 ob0_1 cp0_1 t0_1 0 NCH L=1u W=8u
MDN0_1 o0_1 cn0_1 t0_1 0 NCH L=1u W=8u
RDP0_1 vdd ob0_1 10k
RDN0_1 vdd o0_1 10k
MT0_1 t0_1 g_VT0 0 0 NCH L=1u W=8u
COP0_1 o0_1 0 0.1f
COM0_1 ob0_1 0 0.1f

* column pair cp0_2/cn0_2: 16 four-quadrant synapses + bias row
MVA0_0_2P cp0_2 g_VA0_0_2 bp 0 NCH L=1u W=4u
MVB0_0_2P cp0_2 g_VB0_0_2 bm 0 NCH L=1u W=4u
MVB0_0_2N cn0_2 g_VB0_0_2 bp 0 NCH L=1u W=4u
MVA0_0_2N cn0_2 g_VA0_0_2 bm 0 NCH L=1u W=4u
MVA0_1_2P cp0_2 g_VA0_1_2 xp1 0 NCH L=1u W=4u
MVB0_1_2P cp0_2 g_VB0_1_2 xm1 0 NCH L=1u W=4u
MVB0_1_2N cn0_2 g_VB0_1_2 xp1 0 NCH L=1u W=4u
MVA0_1_2N cn0_2 g_VA0_1_2 xm1 0 NCH L=1u W=4u
MVA0_2_2P cp0_2 g_VA0_2_2 xp2 0 NCH L=1u W=4u
MVB0_2_2P cp0_2 g_VB0_2_2 xm2 0 NCH L=1u W=4u
MVB0_2_2N cn0_2 g_VB0_2_2 xp2 0 NCH L=1u W=4u
MVA0_2_2N cn0_2 g_VA0_2_2 xm2 0 NCH L=1u W=4u
MVA0_3_2P cp0_2 g_VA0_3_2 xp3 0 NCH L=1u W=4u
MVB0_3_2P cp0_2 g_VB0_3_2 xm3 0 NCH L=1u W=4u
MVB0_3_2N cn0_2 g_VB0_3_2 xp3 0 NCH L=1u W=4u
MVA0_3_2N cn0_2 g_VA0_3_2 xm3 0 NCH L=1u W=4u
MVA0_4_2P cp0_2 g_VA0_4_2 xp4 0 NCH L=1u W=4u
MVB0_4_2P cp0_2 g_VB0_4_2 xm4 0 NCH L=1u W=4u
MVB0_4_2N cn0_2 g_VB0_4_2 xp4 0 NCH L=1u W=4u
MVA0_4_2N cn0_2 g_VA0_4_2 xm4 0 NCH L=1u W=4u
MVA0_5_2P cp0_2 g_VA0_5_2 xp5 0 NCH L=1u W=4u
MVB0_5_2P cp0_2 g_VB0_5_2 xm5 0 NCH L=1u W=4u
MVB0_5_2N cn0_2 g_VB0_5_2 xp5 0 NCH L=1u W=4u
MVA0_5_2N cn0_2 g_VA0_5_2 xm5 0 NCH L=1u W=4u
MVA0_6_2P cp0_2 g_VA0_6_2 xp6 0 NCH L=1u W=4u
MVB0_6_2P cp0_2 g_VB0_6_2 xm6 0 NCH L=1u W=4u
MVB0_6_2N cn0_2 g_VB0_6_2 xp6 0 NCH L=1u W=4u
MVA0_6_2N cn0_2 g_VA0_6_2 xm6 0 NCH L=1u W=4u
MVA0_7_2P cp0_2 g_VA0_7_2 xp7 0 NCH L=1u W=4u
MVB0_7_2P cp0_2 g_VB0_7_2 xm7 0 NCH L=1u W=4u
MVB0_7_2N cn0_2 g_VB0_7_2 xp7 0 NCH L=1u W=4u
MVA0_7_2N cn0_2 g_VA0_7_2 xm7 0 NCH L=1u W=4u
MVA0_8_2P cp0_2 g_VA0_8_2 xp8 0 NCH L=1u W=4u
MVB0_8_2P cp0_2 g_VB0_8_2 xm8 0 NCH L=1u W=4u
MVB0_8_2N cn0_2 g_VB0_8_2 xp8 0 NCH L=1u W=4u
MVA0_8_2N cn0_2 g_VA0_8_2 xm8 0 NCH L=1u W=4u
MVA0_9_2P cp0_2 g_VA0_9_2 xp9 0 NCH L=1u W=4u
MVB0_9_2P cp0_2 g_VB0_9_2 xm9 0 NCH L=1u W=4u
MVB0_9_2N cn0_2 g_VB0_9_2 xp9 0 NCH L=1u W=4u
MVA0_9_2N cn0_2 g_VA0_9_2 xm9 0 NCH L=1u W=4u
MVA0_10_2P cp0_2 g_VA0_10_2 xp10 0 NCH L=1u W=4u
MVB0_10_2P cp0_2 g_VB0_10_2 xm10 0 NCH L=1u W=4u
MVB0_10_2N cn0_2 g_VB0_10_2 xp10 0 NCH L=1u W=4u
MVA0_10_2N cn0_2 g_VA0_10_2 xm10 0 NCH L=1u W=4u
MVA0_11_2P cp0_2 g_VA0_11_2 xp11 0 NCH L=1u W=4u
MVB0_11_2P cp0_2 g_VB0_11_2 xm11 0 NCH L=1u W=4u
MVB0_11_2N cn0_2 g_VB0_11_2 xp11 0 NCH L=1u W=4u
MVA0_11_2N cn0_2 g_VA0_11_2 xm11 0 NCH L=1u W=4u
MVA0_12_2P cp0_2 g_VA0_12_2 xp12 0 NCH L=1u W=4u
MVB0_12_2P cp0_2 g_VB0_12_2 xm12 0 NCH L=1u W=4u
MVB0_12_2N cn0_2 g_VB0_12_2 xp12 0 NCH L=1u W=4u
MVA0_12_2N cn0_2 g_VA0_12_2 xm12 0 NCH L=1u W=4u
MVA0_13_2P cp0_2 g_VA0_13_2 xp13 0 NCH L=1u W=4u
MVB0_13_2P cp0_2 g_VB0_13_2 xm13 0 NCH L=1u W=4u
MVB0_13_2N cn0_2 g_VB0_13_2 xp13 0 NCH L=1u W=4u
MVA0_13_2N cn0_2 g_VA0_13_2 xm13 0 NCH L=1u W=4u
MVA0_14_2P cp0_2 g_VA0_14_2 xp14 0 NCH L=1u W=4u
MVB0_14_2P cp0_2 g_VB0_14_2 xm14 0 NCH L=1u W=4u
MVB0_14_2N cn0_2 g_VB0_14_2 xp14 0 NCH L=1u W=4u
MVA0_14_2N cn0_2 g_VA0_14_2 xm14 0 NCH L=1u W=4u
MVA0_15_2P cp0_2 g_VA0_15_2 xp15 0 NCH L=1u W=4u
MVB0_15_2P cp0_2 g_VB0_15_2 xm15 0 NCH L=1u W=4u
MVB0_15_2N cn0_2 g_VB0_15_2 xp15 0 NCH L=1u W=4u
MVA0_15_2N cn0_2 g_VA0_15_2 xm15 0 NCH L=1u W=4u
MVA0_16_2P cp0_2 g_VA0_16_2 xp16 0 NCH L=1u W=4u
MVB0_16_2P cp0_2 g_VB0_16_2 xm16 0 NCH L=1u W=4u
MVB0_16_2N cn0_2 g_VB0_16_2 xp16 0 NCH L=1u W=4u
MVA0_16_2N cn0_2 g_VA0_16_2 xm16 0 NCH L=1u W=4u
RLP0_2 vdd cp0_2 3660
RLN0_2 vdd cn0_2 3660
CCP0_2 cp0_2 0 0.1f
CCN0_2 cn0_2 0 0.1f
MDP0_2 ob0_2 cp0_2 t0_2 0 NCH L=1u W=8u
MDN0_2 o0_2 cn0_2 t0_2 0 NCH L=1u W=8u
RDP0_2 vdd ob0_2 10k
RDN0_2 vdd o0_2 10k
MT0_2 t0_2 g_VT0 0 0 NCH L=1u W=8u
COP0_2 o0_2 0 0.1f
COM0_2 ob0_2 0 0.1f

* column pair cp0_3/cn0_3: 16 four-quadrant synapses + bias row
MVA0_0_3P cp0_3 g_VA0_0_3 bp 0 NCH L=1u W=4u
MVB0_0_3P cp0_3 g_VB0_0_3 bm 0 NCH L=1u W=4u
MVB0_0_3N cn0_3 g_VB0_0_3 bp 0 NCH L=1u W=4u
MVA0_0_3N cn0_3 g_VA0_0_3 bm 0 NCH L=1u W=4u
MVA0_1_3P cp0_3 g_VA0_1_3 xp1 0 NCH L=1u W=4u
MVB0_1_3P cp0_3 g_VB0_1_3 xm1 0 NCH L=1u W=4u
MVB0_1_3N cn0_3 g_VB0_1_3 xp1 0 NCH L=1u W=4u
MVA0_1_3N cn0_3 g_VA0_1_3 xm1 0 NCH L=1u W=4u
MVA0_2_3P cp0_3 g_VA0_2_3 xp2 0 NCH L=1u W=4u
MVB0_2_3P cp0_3 g_VB0_2_3 xm2 0 NCH L=1u W=4u
MVB0_2_3N cn0_3 g_VB0_2_3 xp2 0 NCH L=1u W=4u
MVA0_2_3N cn0_3 g_VA0_2_3 xm2 0 NCH L=1u W=4u
MVA0_3_3P cp0_3 g_VA0_3_3 xp3 0 NCH L=1u W=4u
MVB0_3_3P cp0_3 g_VB0_3_3 xm3 0 NCH L=1u W=4u
MVB0_3_3N cn0_3 g_VB0_3_3 xp3 0 NCH L=1u W=4u
MVA0_3_3N cn0_3 g_VA0_3_3 xm3 0 NCH L=1u W=4u
MVA0_4_3P cp0_3 g_VA0_4_3 xp4 0 NCH L=1u W=4u
MVB0_4_3P cp0_3 g_VB0_4_3 xm4 0 NCH L=1u W=4u
MVB0_4_3N cn0_3 g_VB0_4_3 xp4 0 NCH L=1u W=4u
MVA0_4_3N cn0_3 g_VA0_4_3 xm4 0 NCH L=1u W=4u
MVA0_5_3P cp0_3 g_VA0_5_3 xp5 0 NCH L=1u W=4u
MVB0_5_3P cp0_3 g_VB0_5_3 xm5 0 NCH L=1u W=4u
MVB0_5_3N cn0_3 g_VB0_5_3 xp5 0 NCH L=1u W=4u
MVA0_5_3N cn0_3 g_VA0_5_3 xm5 0 NCH L=1u W=4u
MVA0_6_3P cp0_3 g_VA0_6_3 xp6 0 NCH L=1u W=4u
MVB0_6_3P cp0_3 g_VB0_6_3 xm6 0 NCH L=1u W=4u
MVB0_6_3N cn0_3 g_VB0_6_3 xp6 0 NCH L=1u W=4u
MVA0_6_3N cn0_3 g_VA0_6_3 xm6 0 NCH L=1u W=4u
MVA0_7_3P cp0_3 g_VA0_7_3 xp7 0 NCH L=1u W=4u
MVB0_7_3P cp0_3 g_VB0_7_3 xm7 0 NCH L=1u W=4u
MVB0_7_3N cn0_3 g_VB0_7_3 xp7 0 NCH L=1u W=4u
MVA0_7_3N cn0_3 g_VA0_7_3 xm7 0 NCH L=1u W=4u
MVA0_8_3P cp0_3 g_VA0_8_3 xp8 0 NCH L=1u W=4u
MVB0_8_3P cp0_3 g_VB0_8_3 xm8 0 NCH L=1u W=4u
MVB0_8_3N cn0_3 g_VB0_8_3 xp8 0 NCH L=1u W=4u
MVA0_8_3N cn0_3 g_VA0_8_3 xm8 0 NCH L=1u W=4u
MVA0_9_3P cp0_3 g_VA0_9_3 xp9 0 NCH L=1u W=4u
MVB0_9_3P cp0_3 g_VB0_9_3 xm9 0 NCH L=1u W=4u
MVB0_9_3N cn0_3 g_VB0_9_3 xp9 0 NCH L=1u W=4u
MVA0_9_3N cn0_3 g_VA0_9_3 xm9 0 NCH L=1u W=4u
MVA0_10_3P cp0_3 g_VA0_10_3 xp10 0 NCH L=1u W=4u
MVB0_10_3P cp0_3 g_VB0_10_3 xm10 0 NCH L=1u W=4u
MVB0_10_3N cn0_3 g_VB0_10_3 xp10 0 NCH L=1u W=4u
MVA0_10_3N cn0_3 g_VA0_10_3 xm10 0 NCH L=1u W=4u
MVA0_11_3P cp0_3 g_VA0_11_3 xp11 0 NCH L=1u W=4u
MVB0_11_3P cp0_3 g_VB0_11_3 xm11 0 NCH L=1u W=4u
MVB0_11_3N cn0_3 g_VB0_11_3 xp11 0 NCH L=1u W=4u
MVA0_11_3N cn0_3 g_VA0_11_3 xm11 0 NCH L=1u W=4u
MVA0_12_3P cp0_3 g_VA0_12_3 xp12 0 NCH L=1u W=4u
MVB0_12_3P cp0_3 g_VB0_12_3 xm12 0 NCH L=1u W=4u
MVB0_12_3N cn0_3 g_VB0_12_3 xp12 0 NCH L=1u W=4u
MVA0_12_3N cn0_3 g_VA0_12_3 xm12 0 NCH L=1u W=4u
MVA0_13_3P cp0_3 g_VA0_13_3 xp13 0 NCH L=1u W=4u
MVB0_13_3P cp0_3 g_VB0_13_3 xm13 0 NCH L=1u W=4u
MVB0_13_3N cn0_3 g_VB0_13_3 xp13 0 NCH L=1u W=4u
MVA0_13_3N cn0_3 g_VA0_13_3 xm13 0 NCH L=1u W=4u
MVA0_14_3P cp0_3 g_VA0_14_3 xp14 0 NCH L=1u W=4u
MVB0_14_3P cp0_3 g_VB0_14_3 xm14 0 NCH L=1u W=4u
MVB0_14_3N cn0_3 g_VB0_14_3 xp14 0 NCH L=1u W=4u
MVA0_14_3N cn0_3 g_VA0_14_3 xm14 0 NCH L=1u W=4u
MVA0_15_3P cp0_3 g_VA0_15_3 xp15 0 NCH L=1u W=4u
MVB0_15_3P cp0_3 g_VB0_15_3 xm15 0 NCH L=1u W=4u
MVB0_15_3N cn0_3 g_VB0_15_3 xp15 0 NCH L=1u W=4u
MVA0_15_3N cn0_3 g_VA0_15_3 xm15 0 NCH L=1u W=4u
MVA0_16_3P cp0_3 g_VA0_16_3 xp16 0 NCH L=1u W=4u
MVB0_16_3P cp0_3 g_VB0_16_3 xm16 0 NCH L=1u W=4u
MVB0_16_3N cn0_3 g_VB0_16_3 xp16 0 NCH L=1u W=4u
MVA0_16_3N cn0_3 g_VA0_16_3 xm16 0 NCH L=1u W=4u
RLP0_3 vdd cp0_3 3660
RLN0_3 vdd cn0_3 3660
CCP0_3 cp0_3 0 0.1f
CCN0_3 cn0_3 0 0.1f
MDP0_3 ob0_3 cp0_3 t0_3 0 NCH L=1u W=8u
MDN0_3 o0_3 cn0_3 t0_3 0 NCH L=1u W=8u
RDP0_3 vdd ob0_3 10k
RDN0_3 vdd o0_3 10k
MT0_3 t0_3 g_VT0 0 0 NCH L=1u W=8u
COP0_3 o0_3 0 0.1f
COM0_3 ob0_3 0 0.1f

* column pair cp0_4/cn0_4: 16 four-quadrant synapses + bias row
MVA0_0_4P cp0_4 g_VA0_0_4 bp 0 NCH L=1u W=4u
MVB0_0_4P cp0_4 g_VB0_0_4 bm 0 NCH L=1u W=4u
MVB0_0_4N cn0_4 g_VB0_0_4 bp 0 NCH L=1u W=4u
MVA0_0_4N cn0_4 g_VA0_0_4 bm 0 NCH L=1u W=4u
MVA0_1_4P cp0_4 g_VA0_1_4 xp1 0 NCH L=1u W=4u
MVB0_1_4P cp0_4 g_VB0_1_4 xm1 0 NCH L=1u W=4u
MVB0_1_4N cn0_4 g_VB0_1_4 xp1 0 NCH L=1u W=4u
MVA0_1_4N cn0_4 g_VA0_1_4 xm1 0 NCH L=1u W=4u
MVA0_2_4P cp0_4 g_VA0_2_4 xp2 0 NCH L=1u W=4u
MVB0_2_4P cp0_4 g_VB0_2_4 xm2 0 NCH L=1u W=4u
MVB0_2_4N cn0_4 g_VB0_2_4 xp2 0 NCH L=1u W=4u
MVA0_2_4N cn0_4 g_VA0_2_4 xm2 0 NCH L=1u W=4u
MVA0_3_4P cp0_4 g_VA0_3_4 xp3 0 NCH L=1u W=4u
MVB0_3_4P cp0_4 g_VB0_3_4 xm3 0 NCH L=1u W=4u
MVB0_3_4N cn0_4 g_VB0_3_4 xp3 0 NCH L=1u W=4u
MVA0_3_4N cn0_4 g_VA0_3_4 xm3 0 NCH L=1u W=4u
MVA0_4_4P cp0_4 g_VA0_4_4 xp4 0 NCH L=1u W=4u
MVB0_4_4P cp0_4 g_VB0_4_4 xm4 0 NCH L=1u W=4u
MVB0_4_4N cn0_4 g_VB0_4_4 xp4 0 NCH L=1u W=4u
MVA0_4_4N cn0_4 g_VA0_4_4 xm4 0 NCH L=1u W=4u
MVA0_5_4P cp0_4 g_VA0_5_4 xp5 0 NCH L=1u W=4u
MVB0_5_4P cp0_4 g_VB0_5_4 xm5 0 NCH L=1u W=4u
MVB0_5_4N cn0_4 g_VB0_5_4 xp5 0 NCH L=1u W=4u
MVA0_5_4N cn0_4 g_VA0_5_4 xm5 0 NCH L=1u W=4u
MVA0_6_4P cp0_4 g_VA0_6_4 xp6 0 NCH L=1u W=4u
MVB0_6_4P cp0_4 g_VB0_6_4 xm6 0 NCH L=1u W=4u
MVB0_6_4N cn0_4 g_VB0_6_4 xp6 0 NCH L=1u W=4u
MVA0_6_4N cn0_4 g_VA0_6_4 xm6 0 NCH L=1u W=4u
MVA0_7_4P cp0_4 g_VA0_7_4 xp7 0 NCH L=1u W=4u
MVB0_7_4P cp0_4 g_VB0_7_4 xm7 0 NCH L=1u W=4u
MVB0_7_4N cn0_4 g_VB0_7_4 xp7 0 NCH L=1u W=4u
MVA0_7_4N cn0_4 g_VA0_7_4 xm7 0 NCH L=1u W=4u
MVA0_8_4P cp0_4 g_VA0_8_4 xp8 0 NCH L=1u W=4u
MVB0_8_4P cp0_4 g_VB0_8_4 xm8 0 NCH L=1u W=4u
MVB0_8_4N cn0_4 g_VB0_8_4 xp8 0 NCH L=1u W=4u
MVA0_8_4N cn0_4 g_VA0_8_4 xm8 0 NCH L=1u W=4u
MVA0_9_4P cp0_4 g_VA0_9_4 xp9 0 NCH L=1u W=4u
MVB0_9_4P cp0_4 g_VB0_9_4 xm9 0 NCH L=1u W=4u
MVB0_9_4N cn0_4 g_VB0_9_4 xp9 0 NCH L=1u W=4u
MVA0_9_4N cn0_4 g_VA0_9_4 xm9 0 NCH L=1u W=4u
MVA0_10_4P cp0_4 g_VA0_10_4 xp10 0 NCH L=1u W=4u
MVB0_10_4P cp0_4 g_VB0_10_4 xm10 0 NCH L=1u W=4u
MVB0_10_4N cn0_4 g_VB0_10_4 xp10 0 NCH L=1u W=4u
MVA0_10_4N cn0_4 g_VA0_10_4 xm10 0 NCH L=1u W=4u
MVA0_11_4P cp0_4 g_VA0_11_4 xp11 0 NCH L=1u W=4u
MVB0_11_4P cp0_4 g_VB0_11_4 xm11 0 NCH L=1u W=4u
MVB0_11_4N cn0_4 g_VB0_11_4 xp11 0 NCH L=1u W=4u
MVA0_11_4N cn0_4 g_VA0_11_4 xm11 0 NCH L=1u W=4u
MVA0_12_4P cp0_4 g_VA0_12_4 xp12 0 NCH L=1u W=4u
MVB0_12_4P cp0_4 g_VB0_12_4 xm12 0 NCH L=1u W=4u
MVB0_12_4N cn0_4 g_VB0_12_4 xp12 0 NCH L=1u W=4u
MVA0_12_4N cn0_4 g_VA0_12_4 xm12 0 NCH L=1u W=4u
MVA0_13_4P cp0_4 g_VA0_13_4 xp13 0 NCH L=1u W=4u
MVB0_13_4P cp0_4 g_VB0_13_4 xm13 0 NCH L=1u W=4u
MVB0_13_4N cn0_4 g_VB0_13_4 xp13 0 NCH L=1u W=4u
MVA0_13_4N cn0_4 g_VA0_13_4 xm13 0 NCH L=1u W=4u
MVA0_14_4P cp0_4 g_VA0_14_4 xp14 0 NCH L=1u W=4u
MVB0_14_4P cp0_4 g_VB0_14_4 xm14 0 NCH L=1u W=4u
MVB0_14_4N cn0_4 g_VB0_14_4 xp14 0 NCH L=1u W=4u
MVA0_14_4N cn0_4 g_VA0_14_4 xm14 0 NCH L=1u W=4u
MVA0_15_4P cp0_4 g_VA0_15_4 xp15 0 NCH L=1u W=4u
MVB0_15_4P cp0_4 g_VB0_15_4 xm15 0 NCH L=1u W=4u
MVB0_15_4N cn0_4 g_VB0_15_4 xp15 0 NCH L=1u W=4u
MVA0_15_4N cn0_4 g_VA0_15_4 xm15 0 NCH L=1u W=4u
MVA0_16_4P cp0_4 g_VA0_16_4 xp16 0 NCH L=1u W=4u
MVB0_16_4P cp0_4 g_VB0_16_4 xm16 0 NCH L=1u W=4u
MVB0_16_4N cn0_4 g_VB0_16_4 xp16 0 NCH L=1u W=4u
MVA0_16_4N cn0_4 g_VA0_16_4 xm16 0 NCH L=1u W=4u
RLP0_4 vdd cp0_4 3660
RLN0_4 vdd cn0_4 3660
CCP0_4 cp0_4 0 0.1f
CCN0_4 cn0_4 0 0.1f
MDP0_4 ob0_4 cp0_4 t0_4 0 NCH L=1u W=8u
MDN0_4 o0_4 cn0_4 t0_4 0 NCH L=1u W=8u
RDP0_4 vdd ob0_4 10k
RDN0_4 vdd o0_4 10k
MT0_4 t0_4 g_VT0 0 0 NCH L=1u W=8u
COP0_4 o0_4 0 0.1f
COM0_4 ob0_4 0 0.1f

* column pair cp0_5/cn0_5: 16 four-quadrant synapses + bias row
MVA0_0_5P cp0_5 g_VA0_0_5 bp 0 NCH L=1u W=4u
MVB0_0_5P cp0_5 g_VB0_0_5 bm 0 NCH L=1u W=4u
MVB0_0_5N cn0_5 g_VB0_0_5 bp 0 NCH L=1u W=4u
MVA0_0_5N cn0_5 g_VA0_0_5 bm 0 NCH L=1u W=4u
MVA0_1_5P cp0_5 g_VA0_1_5 xp1 0 NCH L=1u W=4u
MVB0_1_5P cp0_5 g_VB0_1_5 xm1 0 NCH L=1u W=4u
MVB0_1_5N cn0_5 g_VB0_1_5 xp1 0 NCH L=1u W=4u
MVA0_1_5N cn0_5 g_VA0_1_5 xm1 0 NCH L=1u W=4u
MVA0_2_5P cp0_5 g_VA0_2_5 xp2 0 NCH L=1u W=4u
MVB0_2_5P cp0_5 g_VB0_2_5 xm2 0 NCH L=1u W=4u
MVB0_2_5N cn0_5 g_VB0_2_5 xp2 0 NCH L=1u W=4u
MVA0_2_5N cn0_5 g_VA0_2_5 xm2 0 NCH L=1u W=4u
MVA0_3_5P cp0_5 g_VA0_3_5 xp3 0 NCH L=1u W=4u
MVB0_3_5P cp0_5 g_VB0_3_5 xm3 0 NCH L=1u W=4u
MVB0_3_5N cn0_5 g_VB0_3_5 xp3 0 NCH L=1u W=4u
MVA0_3_5N cn0_5 g_VA0_3_5 xm3 0 NCH L=1u W=4u
MVA0_4_5P cp0_5 g_VA0_4_5 xp4 0 NCH L=1u W=4u
MVB0_4_5P cp0_5 g_VB0_4_5 xm4 0 NCH L=1u W=4u
MVB0_4_5N cn0_5 g_VB0_4_5 xp4 0 NCH L=1u W=4u
MVA0_4_5N cn0_5 g_VA0_4_5 xm4 0 NCH L=1u W=4u
MVA0_5_5P cp0_5 g_VA0_5_5 xp5 0 NCH L=1u W=4u
MVB0_5_5P cp0_5 g_VB0_5_5 xm5 0 NCH L=1u W=4u
MVB0_5_5N cn0_5 g_VB0_5_5 xp5 0 NCH L=1u W=4u
MVA0_5_5N cn0_5 g_VA0_5_5 xm5 0 NCH L=1u W=4u
MVA0_6_5P cp0_5 g_VA0_6_5 xp6 0 NCH L=1u W=4u
MVB0_6_5P cp0_5 g_VB0_6_5 xm6 0 NCH L=1u W=4u
MVB0_6_5N cn0_5 g_VB0_6_5 xp6 0 NCH L=1u W=4u
MVA0_6_5N cn0_5 g_VA0_6_5 xm6 0 NCH L=1u W=4u
MVA0_7_5P cp0_5 g_VA0_7_5 xp7 0 NCH L=1u W=4u
MVB0_7_5P cp0_5 g_VB0_7_5 xm7 0 NCH L=1u W=4u
MVB0_7_5N cn0_5 g_VB0_7_5 xp7 0 NCH L=1u W=4u
MVA0_7_5N cn0_5 g_VA0_7_5 xm7 0 NCH L=1u W=4u
MVA0_8_5P cp0_5 g_VA0_8_5 xp8 0 NCH L=1u W=4u
MVB0_8_5P cp0_5 g_VB0_8_5 xm8 0 NCH L=1u W=4u
MVB0_8_5N cn0_5 g_VB0_8_5 xp8 0 NCH L=1u W=4u
MVA0_8_5N cn0_5 g_VA0_8_5 xm8 0 NCH L=1u W=4u
MVA0_9_5P cp0_5 g_VA0_9_5 xp9 0 NCH L=1u W=4u
MVB0_9_5P cp0_5 g_VB0_9_5 xm9 0 NCH L=1u W=4u
MVB0_9_5N cn0_5 g_VB0_9_5 xp9 0 NCH L=1u W=4u
MVA0_9_5N cn0_5 g_VA0_9_5 xm9 0 NCH L=1u W=4u
MVA0_10_5P cp0_5 g_VA0_10_5 xp10 0 NCH L=1u W=4u
MVB0_10_5P cp0_5 g_VB0_10_5 xm10 0 NCH L=1u W=4u
MVB0_10_5N cn0_5 g_VB0_10_5 xp10 0 NCH L=1u W=4u
MVA0_10_5N cn0_5 g_VA0_10_5 xm10 0 NCH L=1u W=4u
MVA0_11_5P cp0_5 g_VA0_11_5 xp11 0 NCH L=1u W=4u
MVB0_11_5P cp0_5 g_VB0_11_5 xm11 0 NCH L=1u W=4u
MVB0_11_5N cn0_5 g_VB0_11_5 xp11 0 NCH L=1u W=4u
MVA0_11_5N cn0_5 g_VA0_11_5 xm11 0 NCH L=1u W=4u
MVA0_12_5P cp0_5 g_VA0_12_5 xp12 0 NCH L=1u W=4u
MVB0_12_5P cp0_5 g_VB0_12_5 xm12 0 NCH L=1u W=4u
MVB0_12_5N cn0_5 g_VB0_12_5 xp12 0 NCH L=1u W=4u
MVA0_12_5N cn0_5 g_VA0_12_5 xm12 0 NCH L=1u W=4u
MVA0_13_5P cp0_5 g_VA0_13_5 xp13 0 NCH L=1u W=4u
MVB0_13_5P cp0_5 g_VB0_13_5 xm13 0 NCH L=1u W=4u
MVB0_13_5N cn0_5 g_VB0_13_5 xp13 0 NCH L=1u W=4u
MVA0_13_5N cn0_5 g_VA0_13_5 xm13 0 NCH L=1u W=4u
MVA0_14_5P cp0_5 g_VA0_14_5 xp14 0 NCH L=1u W=4u
MVB0_14_5P cp0_5 g_VB0_14_5 xm14 0 NCH L=1u W=4u
MVB0_14_5N cn0_5 g_VB0_14_5 xp14 0 NCH L=1u W=4u
MVA0_14_5N cn0_5 g_VA0_14_5 xm14 0 NCH L=1u W=4u
MVA0_15_5P cp0_5 g_VA0_15_5 xp15 0 NCH L=1u W=4u
MVB0_15_5P cp0_5 g_VB0_15_5 xm15 0 NCH L=1u W=4u
MVB0_15_5N cn0_5 g_VB0_15_5 xp15 0 NCH L=1u W=4u
MVA0_15_5N cn0_5 g_VA0_15_5 xm15 0 NCH L=1u W=4u
MVA0_16_5P cp0_5 g_VA0_16_5 xp16 0 NCH L=1u W=4u
MVB0_16_5P cp0_5 g_VB0_16_5 xm16 0 NCH L=1u W=4u
MVB0_16_5N cn0_5 g_VB0_16_5 xp16 0 NCH L=1u W=4u
MVA0_16_5N cn0_5 g_VA0_16_5 xm16 0 NCH L=1u W=4u
RLP0_5 vdd cp0_5 3660
RLN0_5 vdd cn0_5 3660
CCP0_5 cp0_5 0 0.1f
CCN0_5 cn0_5 0 0.1f
MDP0_5 ob0_5 cp0_5 t0_5 0 NCH L=1u W=8u
MDN0_5 o0_5 cn0_5 t0_5 0 NCH L=1u W=8u
RDP0_5 vdd ob0_5 10k
RDN0_5 vdd o0_5 10k
MT0_5 t0_5 g_VT0 0 0 NCH L=1u W=8u
COP0_5 o0_5 0 0.1f
COM0_5 ob0_5 0 0.1f

* column pair cp0_6/cn0_6: 16 four-quadrant synapses + bias row
MVA0_0_6P cp0_6 g_VA0_0_6 bp 0 NCH L=1u W=4u
MVB0_0_6P cp0_6 g_VB0_0_6 bm 0 NCH L=1u W=4u
MVB0_0_6N cn0_6 g_VB0_0_6 bp 0 NCH L=1u W=4u
MVA0_0_6N cn0_6 g_VA0_0_6 bm 0 NCH L=1u W=4u
MVA0_1_6P cp0_6 g_VA0_1_6 xp1 0 NCH L=1u W=4u
MVB0_1_6P cp0_6 g_VB0_1_6 xm1 0 NCH L=1u W=4u
MVB0_1_6N cn0_6 g_VB0_1_6 xp1 0 NCH L=1u W=4u
MVA0_1_6N cn0_6 g_VA0_1_6 xm1 0 NCH L=1u W=4u
MVA0_2_6P cp0_6 g_VA0_2_6 xp2 0 NCH L=1u W=4u
MVB0_2_6P cp0_6 g_VB0_2_6 xm2 0 NCH L=1u W=4u
MVB0_2_6N cn0_6 g_VB0_2_6 xp2 0 NCH L=1u W=4u
MVA0_2_6N cn0_6 g_VA0_2_6 xm2 0 NCH L=1u W=4u
MVA0_3_6P cp0_6 g_VA0_3_6 xp3 0 NCH L=1u W=4u
MVB0_3_6P cp0_6 g_VB0_3_6 xm3 0 NCH L=1u W=4u
MVB0_3_6N cn0_6 g_VB0_3_6 xp3 0 NCH L=1u W=4u
MVA0_3_6N cn0_6 g_VA0_3_6 xm3 0 NCH L=1u W=4u
MVA0_4_6P cp0_6 g_VA0_4_6 xp4 0 NCH L=1u W=4u
MVB0_4_6P cp0_6 g_VB0_4_6 xm4 0 NCH L=1u W=4u
MVB0_4_6N cn0_6 g_VB0_4_6 xp4 0 NCH L=1u W=4u
MVA0_4_6N cn0_6 g_VA0_4_6 xm4 0 NCH L=1u W=4u
MVA0_5_6P cp0_6 g_VA0_5_6 xp5 0 NCH L=1u W=4u
MVB0_5_6P cp0_6 g_VB0_5_6 xm5 0 NCH L=1u W=4u
MVB0_5_6N cn0_6 g_VB0_5_6 xp5 0 NCH L=1u W=4u
MVA0_5_6N cn0_6 g_VA0_5_6 xm5 0 NCH L=1u W=4u
MVA0_6_6P cp0_6 g_VA0_6_6 xp6 0 NCH L=1u W=4u
MVB0_6_6P cp0_6 g_VB0_6_6 xm6 0 NCH L=1u W=4u
MVB0_6_6N cn0_6 g_VB0_6_6 xp6 0 NCH L=1u W=4u
MVA0_6_6N cn0_6 g_VA0_6_6 xm6 0 NCH L=1u W=4u
MVA0_7_6P cp0_6 g_VA0_7_6 xp7 0 NCH L=1u W=4u
MVB0_7_6P cp0_6 g_VB0_7_6 xm7 0 NCH L=1u W=4u
MVB0_7_6N cn0_6 g_VB0_7_6 xp7 0 NCH L=1u W=4u
MVA0_7_6N cn0_6 g_VA0_7_6 xm7 0 NCH L=1u W=4u
MVA0_8_6P cp0_6 g_VA0_8_6 xp8 0 NCH L=1u W=4u
MVB0_8_6P cp0_6 g_VB0_8_6 xm8 0 NCH L=1u W=4u
MVB0_8_6N cn0_6 g_VB0_8_6 xp8 0 NCH L=1u W=4u
MVA0_8_6N cn0_6 g_VA0_8_6 xm8 0 NCH L=1u W=4u
MVA0_9_6P cp0_6 g_VA0_9_6 xp9 0 NCH L=1u W=4u
MVB0_9_6P cp0_6 g_VB0_9_6 xm9 0 NCH L=1u W=4u
MVB0_9_6N cn0_6 g_VB0_9_6 xp9 0 NCH L=1u W=4u
MVA0_9_6N cn0_6 g_VA0_9_6 xm9 0 NCH L=1u W=4u
MVA0_10_6P cp0_6 g_VA0_10_6 xp10 0 NCH L=1u W=4u
MVB0_10_6P cp0_6 g_VB0_10_6 xm10 0 NCH L=1u W=4u
MVB0_10_6N cn0_6 g_VB0_10_6 xp10 0 NCH L=1u W=4u
MVA0_10_6N cn0_6 g_VA0_10_6 xm10 0 NCH L=1u W=4u
MVA0_11_6P cp0_6 g_VA0_11_6 xp11 0 NCH L=1u W=4u
MVB0_11_6P cp0_6 g_VB0_11_6 xm11 0 NCH L=1u W=4u
MVB0_11_6N cn0_6 g_VB0_11_6 xp11 0 NCH L=1u W=4u
MVA0_11_6N cn0_6 g_VA0_11_6 xm11 0 NCH L=1u W=4u
MVA0_12_6P cp0_6 g_VA0_12_6 xp12 0 NCH L=1u W=4u
MVB0_12_6P cp0_6 g_VB0_12_6 xm12 0 NCH L=1u W=4u
MVB0_12_6N cn0_6 g_VB0_12_6 xp12 0 NCH L=1u W=4u
MVA0_12_6N cn0_6 g_VA0_12_6 xm12 0 NCH L=1u W=4u
MVA0_13_6P cp0_6 g_VA0_13_6 xp13 0 NCH L=1u W=4u
MVB0_13_6P cp0_6 g_VB0_13_6 xm13 0 NCH L=1u W=4u
MVB0_13_6N cn0_6 g_VB0_13_6 xp13 0 NCH L=1u W=4u
MVA0_13_6N cn0_6 g_VA0_13_6 xm13 0 NCH L=1u W=4u
MVA0_14_6P cp0_6 g_VA0_14_6 xp14 0 NCH L=1u W=4u
MVB0_14_6P cp0_6 g_VB0_14_6 xm14 0 NCH L=1u W=4u
MVB0_14_6N cn0_6 g_VB0_14_6 xp14 0 NCH L=1u W=4u
MVA0_14_6N cn0_6 g_VA0_14_6 xm14 0 NCH L=1u W=4u
MVA0_15_6P cp0_6 g_VA0_15_6 xp15 0 NCH L=1u W=4u
MVB0_15_6P cp0_6 g_VB0_15_6 xm15 0 NCH L=1u W=4u
MVB0_15_6N cn0_6 g_VB0_15_6 xp15 0 NCH L=1u W=4u
MVA0_15_6N cn0_6 g_VA0_15_6 xm15 0 NCH L=1u W=4u
MVA0_16_6P cp0_6 g_VA0_16_6 xp16 0 NCH L=1u W=4u
MVB0_16_6P cp0_6 g_VB0_16_6 xm16 0 NCH L=1u W=4u
MVB0_16_6N cn0_6 g_VB0_16_6 xp16 0 NCH L=1u W=4u
MVA0_16_6N cn0_6 g_VA0_16_6 xm16 0 NCH L=1u W=4u
RLP0_6 vdd cp0_6 3660
RLN0_6 vdd cn0_6 3660
CCP0_6 cp0_6 0 0.1f
CCN0_6 cn0_6 0 0.1f
MDP0_6 ob0_6 cp0_6 t0_6 0 NCH L=1u W=8u
MDN0_6 o0_6 cn0_6 t0_6 0 NCH L=1u W=8u
RDP0_6 vdd ob0_6 10k
RDN0_6 vdd o0_6 10k
MT0_6 t0_6 g_VT0 0 0 NCH L=1u W=8u
COP0_6 o0_6 0 0.1f
COM0_6 ob0_6 0 0.1f

* column pair cp0_7/cn0_7: 16 four-quadrant synapses + bias row
MVA0_0_7P cp0_7 g_VA0_0_7 bp 0 NCH L=1u W=4u
MVB0_0_7P cp0_7 g_VB0_0_7 bm 0 NCH L=1u W=4u
MVB0_0_7N cn0_7 g_VB0_0_7 bp 0 NCH L=1u W=4u
MVA0_0_7N cn0_7 g_VA0_0_7 bm 0 NCH L=1u W=4u
MVA0_1_7P cp0_7 g_VA0_1_7 xp1 0 NCH L=1u W=4u
MVB0_1_7P cp0_7 g_VB0_1_7 xm1 0 NCH L=1u W=4u
MVB0_1_7N cn0_7 g_VB0_1_7 xp1 0 NCH L=1u W=4u
MVA0_1_7N cn0_7 g_VA0_1_7 xm1 0 NCH L=1u W=4u
MVA0_2_7P cp0_7 g_VA0_2_7 xp2 0 NCH L=1u W=4u
MVB0_2_7P cp0_7 g_VB0_2_7 xm2 0 NCH L=1u W=4u
MVB0_2_7N cn0_7 g_VB0_2_7 xp2 0 NCH L=1u W=4u
MVA0_2_7N cn0_7 g_VA0_2_7 xm2 0 NCH L=1u W=4u
MVA0_3_7P cp0_7 g_VA0_3_7 xp3 0 NCH L=1u W=4u
MVB0_3_7P cp0_7 g_VB0_3_7 xm3 0 NCH L=1u W=4u
MVB0_3_7N cn0_7 g_VB0_3_7 xp3 0 NCH L=1u W=4u
MVA0_3_7N cn0_7 g_VA0_3_7 xm3 0 NCH L=1u W=4u
MVA0_4_7P cp0_7 g_VA0_4_7 xp4 0 NCH L=1u W=4u
MVB0_4_7P cp0_7 g_VB0_4_7 xm4 0 NCH L=1u W=4u
MVB0_4_7N cn0_7 g_VB0_4_7 xp4 0 NCH L=1u W=4u
MVA0_4_7N cn0_7 g_VA0_4_7 xm4 0 NCH L=1u W=4u
MVA0_5_7P cp0_7 g_VA0_5_7 xp5 0 NCH L=1u W=4u
MVB0_5_7P cp0_7 g_VB0_5_7 xm5 0 NCH L=1u W=4u
MVB0_5_7N cn0_7 g_VB0_5_7 xp5 0 NCH L=1u W=4u
MVA0_5_7N cn0_7 g_VA0_5_7 xm5 0 NCH L=1u W=4u
MVA0_6_7P cp0_7 g_VA0_6_7 xp6 0 NCH L=1u W=4u
MVB0_6_7P cp0_7 g_VB0_6_7 xm6 0 NCH L=1u W=4u
MVB0_6_7N cn0_7 g_VB0_6_7 xp6 0 NCH L=1u W=4u
MVA0_6_7N cn0_7 g_VA0_6_7 xm6 0 NCH L=1u W=4u
MVA0_7_7P cp0_7 g_VA0_7_7 xp7 0 NCH L=1u W=4u
MVB0_7_7P cp0_7 g_VB0_7_7 xm7 0 NCH L=1u W=4u
MVB0_7_7N cn0_7 g_VB0_7_7 xp7 0 NCH L=1u W=4u
MVA0_7_7N cn0_7 g_VA0_7_7 xm7 0 NCH L=1u W=4u
MVA0_8_7P cp0_7 g_VA0_8_7 xp8 0 NCH L=1u W=4u
MVB0_8_7P cp0_7 g_VB0_8_7 xm8 0 NCH L=1u W=4u
MVB0_8_7N cn0_7 g_VB0_8_7 xp8 0 NCH L=1u W=4u
MVA0_8_7N cn0_7 g_VA0_8_7 xm8 0 NCH L=1u W=4u
MVA0_9_7P cp0_7 g_VA0_9_7 xp9 0 NCH L=1u W=4u
MVB0_9_7P cp0_7 g_VB0_9_7 xm9 0 NCH L=1u W=4u
MVB0_9_7N cn0_7 g_VB0_9_7 xp9 0 NCH L=1u W=4u
MVA0_9_7N cn0_7 g_VA0_9_7 xm9 0 NCH L=1u W=4u
MVA0_10_7P cp0_7 g_VA0_10_7 xp10 0 NCH L=1u W=4u
MVB0_10_7P cp0_7 g_VB0_10_7 xm10 0 NCH L=1u W=4u
MVB0_10_7N cn0_7 g_VB0_10_7 xp10 0 NCH L=1u W=4u
MVA0_10_7N cn0_7 g_VA0_10_7 xm10 0 NCH L=1u W=4u
MVA0_11_7P cp0_7 g_VA0_11_7 xp11 0 NCH L=1u W=4u
MVB0_11_7P cp0_7 g_VB0_11_7 xm11 0 NCH L=1u W=4u
MVB0_11_7N cn0_7 g_VB0_11_7 xp11 0 NCH L=1u W=4u
MVA0_11_7N cn0_7 g_VA0_11_7 xm11 0 NCH L=1u W=4u
MVA0_12_7P cp0_7 g_VA0_12_7 xp12 0 NCH L=1u W=4u
MVB0_12_7P cp0_7 g_VB0_12_7 xm12 0 NCH L=1u W=4u
MVB0_12_7N cn0_7 g_VB0_12_7 xp12 0 NCH L=1u W=4u
MVA0_12_7N cn0_7 g_VA0_12_7 xm12 0 NCH L=1u W=4u
MVA0_13_7P cp0_7 g_VA0_13_7 xp13 0 NCH L=1u W=4u
MVB0_13_7P cp0_7 g_VB0_13_7 xm13 0 NCH L=1u W=4u
MVB0_13_7N cn0_7 g_VB0_13_7 xp13 0 NCH L=1u W=4u
MVA0_13_7N cn0_7 g_VA0_13_7 xm13 0 NCH L=1u W=4u
MVA0_14_7P cp0_7 g_VA0_14_7 xp14 0 NCH L=1u W=4u
MVB0_14_7P cp0_7 g_VB0_14_7 xm14 0 NCH L=1u W=4u
MVB0_14_7N cn0_7 g_VB0_14_7 xp14 0 NCH L=1u W=4u
MVA0_14_7N cn0_7 g_VA0_14_7 xm14 0 NCH L=1u W=4u
MVA0_15_7P cp0_7 g_VA0_15_7 xp15 0 NCH L=1u W=4u
MVB0_15_7P cp0_7 g_VB0_15_7 xm15 0 NCH L=1u W=4u
MVB0_15_7N cn0_7 g_VB0_15_7 xp15 0 NCH L=1u W=4u
MVA0_15_7N cn0_7 g_VA0_15_7 xm15 0 NCH L=1u W=4u
MVA0_16_7P cp0_7 g_VA0_16_7 xp16 0 NCH L=1u W=4u
MVB0_16_7P cp0_7 g_VB0_16_7 xm16 0 NCH L=1u W=4u
MVB0_16_7N cn0_7 g_VB0_16_7 xp16 0 NCH L=1u W=4u
MVA0_16_7N cn0_7 g_VA0_16_7 xm16 0 NCH L=1u W=4u
RLP0_7 vdd cp0_7 3660
RLN0_7 vdd cn0_7 3660
CCP0_7 cp0_7 0 0.1f
CCN0_7 cn0_7 0 0.1f
MDP0_7 ob0_7 cp0_7 t0_7 0 NCH L=1u W=8u
MDN0_7 o0_7 cn0_7 t0_7 0 NCH L=1u W=8u
RDP0_7 vdd ob0_7 10k
RDN0_7 vdd o0_7 10k
MT0_7 t0_7 g_VT0 0 0 NCH L=1u W=8u
COP0_7 o0_7 0 0.1f
COM0_7 ob0_7 0 0.1f

* column pair cp0_8/cn0_8: 16 four-quadrant synapses + bias row
MVA0_0_8P cp0_8 g_VA0_0_8 bp 0 NCH L=1u W=4u
MVB0_0_8P cp0_8 g_VB0_0_8 bm 0 NCH L=1u W=4u
MVB0_0_8N cn0_8 g_VB0_0_8 bp 0 NCH L=1u W=4u
MVA0_0_8N cn0_8 g_VA0_0_8 bm 0 NCH L=1u W=4u
MVA0_1_8P cp0_8 g_VA0_1_8 xp1 0 NCH L=1u W=4u
MVB0_1_8P cp0_8 g_VB0_1_8 xm1 0 NCH L=1u W=4u
MVB0_1_8N cn0_8 g_VB0_1_8 xp1 0 NCH L=1u W=4u
MVA0_1_8N cn0_8 g_VA0_1_8 xm1 0 NCH L=1u W=4u
MVA0_2_8P cp0_8 g_VA0_2_8 xp2 0 NCH L=1u W=4u
MVB0_2_8P cp0_8 g_VB0_2_8 xm2 0 NCH L=1u W=4u
MVB0_2_8N cn0_8 g_VB0_2_8 xp2 0 NCH L=1u W=4u
MVA0_2_8N cn0_8 g_VA0_2_8 xm2 0 NCH L=1u W=4u
MVA0_3_8P cp0_8 g_VA0_3_8 xp3 0 NCH L=1u W=4u
MVB0_3_8P cp0_8 g_VB0_3_8 xm3 0 NCH L=1u W=4u
MVB0_3_8N cn0_8 g_VB0_3_8 xp3 0 NCH L=1u W=4u
MVA0_3_8N cn0_8 g_VA0_3_8 xm3 0 NCH L=1u W=4u
MVA0_4_8P cp0_8 g_VA0_4_8 xp4 0 NCH L=1u W=4u
MVB0_4_8P cp0_8 g_VB0_4_8 xm4 0 NCH L=1u W=4u
MVB0_4_8N cn0_8 g_VB0_4_8 xp4 0 NCH L=1u W=4u
MVA0_4_8N cn0_8 g_VA0_4_8 xm4 0 NCH L=1u W=4u
MVA0_5_8P cp0_8 g_VA0_5_8 xp5 0 NCH L=1u W=4u
MVB0_5_8P cp0_8 g_VB0_5_8 xm5 0 NCH L=1u W=4u
MVB0_5_8N cn0_8 g_VB0_5_8 xp5 0 NCH L=1u W=4u
MVA0_5_8N cn0_8 g_VA0_5_8 xm5 0 NCH L=1u W=4u
MVA0_6_8P cp0_8 g_VA0_6_8 xp6 0 NCH L=1u W=4u
MVB0_6_8P cp0_8 g_VB0_6_8 xm6 0 NCH L=1u W=4u
MVB0_6_8N cn0_8 g_VB0_6_8 xp6 0 NCH L=1u W=4u
MVA0_6_8N cn0_8 g_VA0_6_8 xm6 0 NCH L=1u W=4u
MVA0_7_8P cp0_8 g_VA0_7_8 xp7 0 NCH L=1u W=4u
MVB0_7_8P cp0_8 g_VB0_7_8 xm7 0 NCH L=1u W=4u
MVB0_7_8N cn0_8 g_VB0_7_8 xp7 0 NCH L=1u W=4u
MVA0_7_8N cn0_8 g_VA0_7_8 xm7 0 NCH L=1u W=4u
MVA0_8_8P cp0_8 g_VA0_8_8 xp8 0 NCH L=1u W=4u
MVB0_8_8P cp0_8 g_VB0_8_8 xm8 0 NCH L=1u W=4u
MVB0_8_8N cn0_8 g_VB0_8_8 xp8 0 NCH L=1u W=4u
MVA0_8_8N cn0_8 g_VA0_8_8 xm8 0 NCH L=1u W=4u
MVA0_9_8P cp0_8 g_VA0_9_8 xp9 0 NCH L=1u W=4u
MVB0_9_8P cp0_8 g_VB0_9_8 xm9 0 NCH L=1u W=4u
MVB0_9_8N cn0_8 g_VB0_9_8 xp9 0 NCH L=1u W=4u
MVA0_9_8N cn0_8 g_VA0_9_8 xm9 0 NCH L=1u W=4u
MVA0_10_8P cp0_8 g_VA0_10_8 xp10 0 NCH L=1u W=4u
MVB0_10_8P cp0_8 g_VB0_10_8 xm10 0 NCH L=1u W=4u
MVB0_10_8N cn0_8 g_VB0_10_8 xp10 0 NCH L=1u W=4u
MVA0_10_8N cn0_8 g_VA0_10_8 xm10 0 NCH L=1u W=4u
MVA0_11_8P cp0_8 g_VA0_11_8 xp11 0 NCH L=1u W=4u
MVB0_11_8P cp0_8 g_VB0_11_8 xm11 0 NCH L=1u W=4u
MVB0_11_8N cn0_8 g_VB0_11_8 xp11 0 NCH L=1u W=4u
MVA0_11_8N cn0_8 g_VA0_11_8 xm11 0 NCH L=1u W=4u
MVA0_12_8P cp0_8 g_VA0_12_8 xp12 0 NCH L=1u W=4u
MVB0_12_8P cp0_8 g_VB0_12_8 xm12 0 NCH L=1u W=4u
MVB0_12_8N cn0_8 g_VB0_12_8 xp12 0 NCH L=1u W=4u
MVA0_12_8N cn0_8 g_VA0_12_8 xm12 0 NCH L=1u W=4u
MVA0_13_8P cp0_8 g_VA0_13_8 xp13 0 NCH L=1u W=4u
MVB0_13_8P cp0_8 g_VB0_13_8 xm13 0 NCH L=1u W=4u
MVB0_13_8N cn0_8 g_VB0_13_8 xp13 0 NCH L=1u W=4u
MVA0_13_8N cn0_8 g_VA0_13_8 xm13 0 NCH L=1u W=4u
MVA0_14_8P cp0_8 g_VA0_14_8 xp14 0 NCH L=1u W=4u
MVB0_14_8P cp0_8 g_VB0_14_8 xm14 0 NCH L=1u W=4u
MVB0_14_8N cn0_8 g_VB0_14_8 xp14 0 NCH L=1u W=4u
MVA0_14_8N cn0_8 g_VA0_14_8 xm14 0 NCH L=1u W=4u
MVA0_15_8P cp0_8 g_VA0_15_8 xp15 0 NCH L=1u W=4u
MVB0_15_8P cp0_8 g_VB0_15_8 xm15 0 NCH L=1u W=4u
MVB0_15_8N cn0_8 g_VB0_15_8 xp15 0 NCH L=1u W=4u
MVA0_15_8N cn0_8 g_VA0_15_8 xm15 0 NCH L=1u W=4u
MVA0_16_8P cp0_8 g_VA0_16_8 xp16 0 NCH L=1u W=4u
MVB0_16_8P cp0_8 g_VB0_16_8 xm16 0 NCH L=1u W=4u
MVB0_16_8N cn0_8 g_VB0_16_8 xp16 0 NCH L=1u W=4u
MVA0_16_8N cn0_8 g_VA0_16_8 xm16 0 NCH L=1u W=4u
RLP0_8 vdd cp0_8 3660
RLN0_8 vdd cn0_8 3660
CCP0_8 cp0_8 0 0.1f
CCN0_8 cn0_8 0 0.1f
MDP0_8 ob0_8 cp0_8 t0_8 0 NCH L=1u W=8u
MDN0_8 o0_8 cn0_8 t0_8 0 NCH L=1u W=8u
RDP0_8 vdd ob0_8 10k
RDN0_8 vdd o0_8 10k
MT0_8 t0_8 g_VT0 0 0 NCH L=1u W=8u
COP0_8 o0_8 0 0.1f
COM0_8 ob0_8 0 0.1f

* column pair cp0_9/cn0_9: 16 four-quadrant synapses + bias row
MVA0_0_9P cp0_9 g_VA0_0_9 bp 0 NCH L=1u W=4u
MVB0_0_9P cp0_9 g_VB0_0_9 bm 0 NCH L=1u W=4u
MVB0_0_9N cn0_9 g_VB0_0_9 bp 0 NCH L=1u W=4u
MVA0_0_9N cn0_9 g_VA0_0_9 bm 0 NCH L=1u W=4u
MVA0_1_9P cp0_9 g_VA0_1_9 xp1 0 NCH L=1u W=4u
MVB0_1_9P cp0_9 g_VB0_1_9 xm1 0 NCH L=1u W=4u
MVB0_1_9N cn0_9 g_VB0_1_9 xp1 0 NCH L=1u W=4u
MVA0_1_9N cn0_9 g_VA0_1_9 xm1 0 NCH L=1u W=4u
MVA0_2_9P cp0_9 g_VA0_2_9 xp2 0 NCH L=1u W=4u
MVB0_2_9P cp0_9 g_VB0_2_9 xm2 0 NCH L=1u W=4u
MVB0_2_9N cn0_9 g_VB0_2_9 xp2 0 NCH L=1u W=4u
MVA0_2_9N cn0_9 g_VA0_2_9 xm2 0 NCH L=1u W=4u
MVA0_3_9P cp0_9 g_VA0_3_9 xp3 0 NCH L=1u W=4u
MVB0_3_9P cp0_9 g_VB0_3_9 xm3 0 NCH L=1u W=4u
MVB0_3_9N cn0_9 g_VB0_3_9 xp3 0 NCH L=1u W=4u
MVA0_3_9N cn0_9 g_VA0_3_9 xm3 0 NCH L=1u W=4u
MVA0_4_9P cp0_9 g_VA0_4_9 xp4 0 NCH L=1u W=4u
MVB0_4_9P cp0_9 g_VB0_4_9 xm4 0 NCH L=1u W=4u
MVB0_4_9N cn0_9 g_VB0_4_9 xp4 0 NCH L=1u W=4u
MVA0_4_9N cn0_9 g_VA0_4_9 xm4 0 NCH L=1u W=4u
MVA0_5_9P cp0_9 g_VA0_5_9 xp5 0 NCH L=1u W=4u
MVB0_5_9P cp0_9 g_VB0_5_9 xm5 0 NCH L=1u W=4u
MVB0_5_9N cn0_9 g_VB0_5_9 xp5 0 NCH L=1u W=4u
MVA0_5_9N cn0_9 g_VA0_5_9 xm5 0 NCH L=1u W=4u
MVA0_6_9P cp0_9 g_VA0_6_9 xp6 0 NCH L=1u W=4u
MVB0_6_9P cp0_9 g_VB0_6_9 xm6 0 NCH L=1u W=4u
MVB0_6_9N cn0_9 g_VB0_6_9 xp6 0 NCH L=1u W=4u
MVA0_6_9N cn0_9 g_VA0_6_9 xm6 0 NCH L=1u W=4u
MVA0_7_9P cp0_9 g_VA0_7_9 xp7 0 NCH L=1u W=4u
MVB0_7_9P cp0_9 g_VB0_7_9 xm7 0 NCH L=1u W=4u
MVB0_7_9N cn0_9 g_VB0_7_9 xp7 0 NCH L=1u W=4u
MVA0_7_9N cn0_9 g_VA0_7_9 xm7 0 NCH L=1u W=4u
MVA0_8_9P cp0_9 g_VA0_8_9 xp8 0 NCH L=1u W=4u
MVB0_8_9P cp0_9 g_VB0_8_9 xm8 0 NCH L=1u W=4u
MVB0_8_9N cn0_9 g_VB0_8_9 xp8 0 NCH L=1u W=4u
MVA0_8_9N cn0_9 g_VA0_8_9 xm8 0 NCH L=1u W=4u
MVA0_9_9P cp0_9 g_VA0_9_9 xp9 0 NCH L=1u W=4u
MVB0_9_9P cp0_9 g_VB0_9_9 xm9 0 NCH L=1u W=4u
MVB0_9_9N cn0_9 g_VB0_9_9 xp9 0 NCH L=1u W=4u
MVA0_9_9N cn0_9 g_VA0_9_9 xm9 0 NCH L=1u W=4u
MVA0_10_9P cp0_9 g_VA0_10_9 xp10 0 NCH L=1u W=4u
MVB0_10_9P cp0_9 g_VB0_10_9 xm10 0 NCH L=1u W=4u
MVB0_10_9N cn0_9 g_VB0_10_9 xp10 0 NCH L=1u W=4u
MVA0_10_9N cn0_9 g_VA0_10_9 xm10 0 NCH L=1u W=4u
MVA0_11_9P cp0_9 g_VA0_11_9 xp11 0 NCH L=1u W=4u
MVB0_11_9P cp0_9 g_VB0_11_9 xm11 0 NCH L=1u W=4u
MVB0_11_9N cn0_9 g_VB0_11_9 xp11 0 NCH L=1u W=4u
MVA0_11_9N cn0_9 g_VA0_11_9 xm11 0 NCH L=1u W=4u
MVA0_12_9P cp0_9 g_VA0_12_9 xp12 0 NCH L=1u W=4u
MVB0_12_9P cp0_9 g_VB0_12_9 xm12 0 NCH L=1u W=4u
MVB0_12_9N cn0_9 g_VB0_12_9 xp12 0 NCH L=1u W=4u
MVA0_12_9N cn0_9 g_VA0_12_9 xm12 0 NCH L=1u W=4u
MVA0_13_9P cp0_9 g_VA0_13_9 xp13 0 NCH L=1u W=4u
MVB0_13_9P cp0_9 g_VB0_13_9 xm13 0 NCH L=1u W=4u
MVB0_13_9N cn0_9 g_VB0_13_9 xp13 0 NCH L=1u W=4u
MVA0_13_9N cn0_9 g_VA0_13_9 xm13 0 NCH L=1u W=4u
MVA0_14_9P cp0_9 g_VA0_14_9 xp14 0 NCH L=1u W=4u
MVB0_14_9P cp0_9 g_VB0_14_9 xm14 0 NCH L=1u W=4u
MVB0_14_9N cn0_9 g_VB0_14_9 xp14 0 NCH L=1u W=4u
MVA0_14_9N cn0_9 g_VA0_14_9 xm14 0 NCH L=1u W=4u
MVA0_15_9P cp0_9 g_VA0_15_9 xp15 0 NCH L=1u W=4u
MVB0_15_9P cp0_9 g_VB0_15_9 xm15 0 NCH L=1u W=4u
MVB0_15_9N cn0_9 g_VB0_15_9 xp15 0 NCH L=1u W=4u
MVA0_15_9N cn0_9 g_VA0_15_9 xm15 0 NCH L=1u W=4u
MVA0_16_9P cp0_9 g_VA0_16_9 xp16 0 NCH L=1u W=4u
MVB0_16_9P cp0_9 g_VB0_16_9 xm16 0 NCH L=1u W=4u
MVB0_16_9N cn0_9 g_VB0_16_9 xp16 0 NCH L=1u W=4u
MVA0_16_9N cn0_9 g_VA0_16_9 xm16 0 NCH L=1u W=4u
RLP0_9 vdd cp0_9 3660
RLN0_9 vdd cn0_9 3660
CCP0_9 cp0_9 0 0.1f
CCN0_9 cn0_9 0 0.1f
MDP0_9 ob0_9 cp0_9 t0_9 0 NCH L=1u W=8u
MDN0_9 o0_9 cn0_9 t0_9 0 NCH L=1u W=8u
RDP0_9 vdd ob0_9 10k
RDN0_9 vdd o0_9 10k
MT0_9 t0_9 g_VT0 0 0 NCH L=1u W=8u
COP0_9 o0_9 0 0.1f
COM0_9 ob0_9 0 0.1f

* column pair cp0_10/cn0_10: 16 four-quadrant synapses + bias row
MVA0_0_10P cp0_10 g_VA0_0_10 bp 0 NCH L=1u W=4u
MVB0_0_10P cp0_10 g_VB0_0_10 bm 0 NCH L=1u W=4u
MVB0_0_10N cn0_10 g_VB0_0_10 bp 0 NCH L=1u W=4u
MVA0_0_10N cn0_10 g_VA0_0_10 bm 0 NCH L=1u W=4u
MVA0_1_10P cp0_10 g_VA0_1_10 xp1 0 NCH L=1u W=4u
MVB0_1_10P cp0_10 g_VB0_1_10 xm1 0 NCH L=1u W=4u
MVB0_1_10N cn0_10 g_VB0_1_10 xp1 0 NCH L=1u W=4u
MVA0_1_10N cn0_10 g_VA0_1_10 xm1 0 NCH L=1u W=4u
MVA0_2_10P cp0_10 g_VA0_2_10 xp2 0 NCH L=1u W=4u
MVB0_2_10P cp0_10 g_VB0_2_10 xm2 0 NCH L=1u W=4u
MVB0_2_10N cn0_10 g_VB0_2_10 xp2 0 NCH L=1u W=4u
MVA0_2_10N cn0_10 g_VA0_2_10 xm2 0 NCH L=1u W=4u
MVA0_3_10P cp0_10 g_VA0_3_10 xp3 0 NCH L=1u W=4u
MVB0_3_10P cp0_10 g_VB0_3_10 xm3 0 NCH L=1u W=4u
MVB0_3_10N cn0_10 g_VB0_3_10 xp3 0 NCH L=1u W=4u
MVA0_3_10N cn0_10 g_VA0_3_10 xm3 0 NCH L=1u W=4u
MVA0_4_10P cp0_10 g_VA0_4_10 xp4 0 NCH L=1u W=4u
MVB0_4_10P cp0_10 g_VB0_4_10 xm4 0 NCH L=1u W=4u
MVB0_4_10N cn0_10 g_VB0_4_10 xp4 0 NCH L=1u W=4u
MVA0_4_10N cn0_10 g_VA0_4_10 xm4 0 NCH L=1u W=4u
MVA0_5_10P cp0_10 g_VA0_5_10 xp5 0 NCH L=1u W=4u
MVB0_5_10P cp0_10 g_VB0_5_10 xm5 0 NCH L=1u W=4u
MVB0_5_10N cn0_10 g_VB0_5_10 xp5 0 NCH L=1u W=4u
MVA0_5_10N cn0_10 g_VA0_5_10 xm5 0 NCH L=1u W=4u
MVA0_6_10P cp0_10 g_VA0_6_10 xp6 0 NCH L=1u W=4u
MVB0_6_10P cp0_10 g_VB0_6_10 xm6 0 NCH L=1u W=4u
MVB0_6_10N cn0_10 g_VB0_6_10 xp6 0 NCH L=1u W=4u
MVA0_6_10N cn0_10 g_VA0_6_10 xm6 0 NCH L=1u W=4u
MVA0_7_10P cp0_10 g_VA0_7_10 xp7 0 NCH L=1u W=4u
MVB0_7_10P cp0_10 g_VB0_7_10 xm7 0 NCH L=1u W=4u
MVB0_7_10N cn0_10 g_VB0_7_10 xp7 0 NCH L=1u W=4u
MVA0_7_10N cn0_10 g_VA0_7_10 xm7 0 NCH L=1u W=4u
MVA0_8_10P cp0_10 g_VA0_8_10 xp8 0 NCH L=1u W=4u
MVB0_8_10P cp0_10 g_VB0_8_10 xm8 0 NCH L=1u W=4u
MVB0_8_10N cn0_10 g_VB0_8_10 xp8 0 NCH L=1u W=4u
MVA0_8_10N cn0_10 g_VA0_8_10 xm8 0 NCH L=1u W=4u
MVA0_9_10P cp0_10 g_VA0_9_10 xp9 0 NCH L=1u W=4u
MVB0_9_10P cp0_10 g_VB0_9_10 xm9 0 NCH L=1u W=4u
MVB0_9_10N cn0_10 g_VB0_9_10 xp9 0 NCH L=1u W=4u
MVA0_9_10N cn0_10 g_VA0_9_10 xm9 0 NCH L=1u W=4u
MVA0_10_10P cp0_10 g_VA0_10_10 xp10 0 NCH L=1u W=4u
MVB0_10_10P cp0_10 g_VB0_10_10 xm10 0 NCH L=1u W=4u
MVB0_10_10N cn0_10 g_VB0_10_10 xp10 0 NCH L=1u W=4u
MVA0_10_10N cn0_10 g_VA0_10_10 xm10 0 NCH L=1u W=4u
MVA0_11_10P cp0_10 g_VA0_11_10 xp11 0 NCH L=1u W=4u
MVB0_11_10P cp0_10 g_VB0_11_10 xm11 0 NCH L=1u W=4u
MVB0_11_10N cn0_10 g_VB0_11_10 xp11 0 NCH L=1u W=4u
MVA0_11_10N cn0_10 g_VA0_11_10 xm11 0 NCH L=1u W=4u
MVA0_12_10P cp0_10 g_VA0_12_10 xp12 0 NCH L=1u W=4u
MVB0_12_10P cp0_10 g_VB0_12_10 xm12 0 NCH L=1u W=4u
MVB0_12_10N cn0_10 g_VB0_12_10 xp12 0 NCH L=1u W=4u
MVA0_12_10N cn0_10 g_VA0_12_10 xm12 0 NCH L=1u W=4u
MVA0_13_10P cp0_10 g_VA0_13_10 xp13 0 NCH L=1u W=4u
MVB0_13_10P cp0_10 g_VB0_13_10 xm13 0 NCH L=1u W=4u
MVB0_13_10N cn0_10 g_VB0_13_10 xp13 0 NCH L=1u W=4u
MVA0_13_10N cn0_10 g_VA0_13_10 xm13 0 NCH L=1u W=4u
MVA0_14_10P cp0_10 g_VA0_14_10 xp14 0 NCH L=1u W=4u
MVB0_14_10P cp0_10 g_VB0_14_10 xm14 0 NCH L=1u W=4u
MVB0_14_10N cn0_10 g_VB0_14_10 xp14 0 NCH L=1u W=4u
MVA0_14_10N cn0_10 g_VA0_14_10 xm14 0 NCH L=1u W=4u
MVA0_15_10P cp0_10 g_VA0_15_10 xp15 0 NCH L=1u W=4u
MVB0_15_10P cp0_10 g_VB0_15_10 xm15 0 NCH L=1u W=4u
MVB0_15_10N cn0_10 g_VB0_15_10 xp15 0 NCH L=1u W=4u
MVA0_15_10N cn0_10 g_VA0_15_10 xm15 0 NCH L=1u W=4u
MVA0_16_10P cp0_10 g_VA0_16_10 xp16 0 NCH L=1u W=4u
MVB0_16_10P cp0_10 g_VB0_16_10 xm16 0 NCH L=1u W=4u
MVB0_16_10N cn0_10 g_VB0_16_10 xp16 0 NCH L=1u W=4u
MVA0_16_10N cn0_10 g_VA0_16_10 xm16 0 NCH L=1u W=4u
RLP0_10 vdd cp0_10 3660
RLN0_10 vdd cn0_10 3660
CCP0_10 cp0_10 0 0.1f
CCN0_10 cn0_10 0 0.1f
MDP0_10 ob0_10 cp0_10 t0_10 0 NCH L=1u W=8u
MDN0_10 o0_10 cn0_10 t0_10 0 NCH L=1u W=8u
RDP0_10 vdd ob0_10 10k
RDN0_10 vdd o0_10 10k
MT0_10 t0_10 g_VT0 0 0 NCH L=1u W=8u
COP0_10 o0_10 0 0.1f
COM0_10 ob0_10 0 0.1f

* column pair cp0_11/cn0_11: 16 four-quadrant synapses + bias row
MVA0_0_11P cp0_11 g_VA0_0_11 bp 0 NCH L=1u W=4u
MVB0_0_11P cp0_11 g_VB0_0_11 bm 0 NCH L=1u W=4u
MVB0_0_11N cn0_11 g_VB0_0_11 bp 0 NCH L=1u W=4u
MVA0_0_11N cn0_11 g_VA0_0_11 bm 0 NCH L=1u W=4u
MVA0_1_11P cp0_11 g_VA0_1_11 xp1 0 NCH L=1u W=4u
MVB0_1_11P cp0_11 g_VB0_1_11 xm1 0 NCH L=1u W=4u
MVB0_1_11N cn0_11 g_VB0_1_11 xp1 0 NCH L=1u W=4u
MVA0_1_11N cn0_11 g_VA0_1_11 xm1 0 NCH L=1u W=4u
MVA0_2_11P cp0_11 g_VA0_2_11 xp2 0 NCH L=1u W=4u
MVB0_2_11P cp0_11 g_VB0_2_11 xm2 0 NCH L=1u W=4u
MVB0_2_11N cn0_11 g_VB0_2_11 xp2 0 NCH L=1u W=4u
MVA0_2_11N cn0_11 g_VA0_2_11 xm2 0 NCH L=1u W=4u
MVA0_3_11P cp0_11 g_VA0_3_11 xp3 0 NCH L=1u W=4u
MVB0_3_11P cp0_11 g_VB0_3_11 xm3 0 NCH L=1u W=4u
MVB0_3_11N cn0_11 g_VB0_3_11 xp3 0 NCH L=1u W=4u
MVA0_3_11N cn0_11 g_VA0_3_11 xm3 0 NCH L=1u W=4u
MVA0_4_11P cp0_11 g_VA0_4_11 xp4 0 NCH L=1u W=4u
MVB0_4_11P cp0_11 g_VB0_4_11 xm4 0 NCH L=1u W=4u
MVB0_4_11N cn0_11 g_VB0_4_11 xp4 0 NCH L=1u W=4u
MVA0_4_11N cn0_11 g_VA0_4_11 xm4 0 NCH L=1u W=4u
MVA0_5_11P cp0_11 g_VA0_5_11 xp5 0 NCH L=1u W=4u
MVB0_5_11P cp0_11 g_VB0_5_11 xm5 0 NCH L=1u W=4u
MVB0_5_11N cn0_11 g_VB0_5_11 xp5 0 NCH L=1u W=4u
MVA0_5_11N cn0_11 g_VA0_5_11 xm5 0 NCH L=1u W=4u
MVA0_6_11P cp0_11 g_VA0_6_11 xp6 0 NCH L=1u W=4u
MVB0_6_11P cp0_11 g_VB0_6_11 xm6 0 NCH L=1u W=4u
MVB0_6_11N cn0_11 g_VB0_6_11 xp6 0 NCH L=1u W=4u
MVA0_6_11N cn0_11 g_VA0_6_11 xm6 0 NCH L=1u W=4u
MVA0_7_11P cp0_11 g_VA0_7_11 xp7 0 NCH L=1u W=4u
MVB0_7_11P cp0_11 g_VB0_7_11 xm7 0 NCH L=1u W=4u
MVB0_7_11N cn0_11 g_VB0_7_11 xp7 0 NCH L=1u W=4u
MVA0_7_11N cn0_11 g_VA0_7_11 xm7 0 NCH L=1u W=4u
MVA0_8_11P cp0_11 g_VA0_8_11 xp8 0 NCH L=1u W=4u
MVB0_8_11P cp0_11 g_VB0_8_11 xm8 0 NCH L=1u W=4u
MVB0_8_11N cn0_11 g_VB0_8_11 xp8 0 NCH L=1u W=4u
MVA0_8_11N cn0_11 g_VA0_8_11 xm8 0 NCH L=1u W=4u
MVA0_9_11P cp0_11 g_VA0_9_11 xp9 0 NCH L=1u W=4u
MVB0_9_11P cp0_11 g_VB0_9_11 xm9 0 NCH L=1u W=4u
MVB0_9_11N cn0_11 g_VB0_9_11 xp9 0 NCH L=1u W=4u
MVA0_9_11N cn0_11 g_VA0_9_11 xm9 0 NCH L=1u W=4u
MVA0_10_11P cp0_11 g_VA0_10_11 xp10 0 NCH L=1u W=4u
MVB0_10_11P cp0_11 g_VB0_10_11 xm10 0 NCH L=1u W=4u
MVB0_10_11N cn0_11 g_VB0_10_11 xp10 0 NCH L=1u W=4u
MVA0_10_11N cn0_11 g_VA0_10_11 xm10 0 NCH L=1u W=4u
MVA0_11_11P cp0_11 g_VA0_11_11 xp11 0 NCH L=1u W=4u
MVB0_11_11P cp0_11 g_VB0_11_11 xm11 0 NCH L=1u W=4u
MVB0_11_11N cn0_11 g_VB0_11_11 xp11 0 NCH L=1u W=4u
MVA0_11_11N cn0_11 g_VA0_11_11 xm11 0 NCH L=1u W=4u
MVA0_12_11P cp0_11 g_VA0_12_11 xp12 0 NCH L=1u W=4u
MVB0_12_11P cp0_11 g_VB0_12_11 xm12 0 NCH L=1u W=4u
MVB0_12_11N cn0_11 g_VB0_12_11 xp12 0 NCH L=1u W=4u
MVA0_12_11N cn0_11 g_VA0_12_11 xm12 0 NCH L=1u W=4u
MVA0_13_11P cp0_11 g_VA0_13_11 xp13 0 NCH L=1u W=4u
MVB0_13_11P cp0_11 g_VB0_13_11 xm13 0 NCH L=1u W=4u
MVB0_13_11N cn0_11 g_VB0_13_11 xp13 0 NCH L=1u W=4u
MVA0_13_11N cn0_11 g_VA0_13_11 xm13 0 NCH L=1u W=4u
MVA0_14_11P cp0_11 g_VA0_14_11 xp14 0 NCH L=1u W=4u
MVB0_14_11P cp0_11 g_VB0_14_11 xm14 0 NCH L=1u W=4u
MVB0_14_11N cn0_11 g_VB0_14_11 xp14 0 NCH L=1u W=4u
MVA0_14_11N cn0_11 g_VA0_14_11 xm14 0 NCH L=1u W=4u
MVA0_15_11P cp0_11 g_VA0_15_11 xp15 0 NCH L=1u W=4u
MVB0_15_11P cp0_11 g_VB0_15_11 xm15 0 NCH L=1u W=4u
MVB0_15_11N cn0_11 g_VB0_15_11 xp15 0 NCH L=1u W=4u
MVA0_15_11N cn0_11 g_VA0_15_11 xm15 0 NCH L=1u W=4u
MVA0_16_11P cp0_11 g_VA0_16_11 xp16 0 NCH L=1u W=4u
MVB0_16_11P cp0_11 g_VB0_16_11 xm16 0 NCH L=1u W=4u
MVB0_16_11N cn0_11 g_VB0_16_11 xp16 0 NCH L=1u W=4u
MVA0_16_11N cn0_11 g_VA0_16_11 xm16 0 NCH L=1u W=4u
RLP0_11 vdd cp0_11 3660
RLN0_11 vdd cn0_11 3660
CCP0_11 cp0_11 0 0.1f
CCN0_11 cn0_11 0 0.1f
MDP0_11 ob0_11 cp0_11 t0_11 0 NCH L=1u W=8u
MDN0_11 o0_11 cn0_11 t0_11 0 NCH L=1u W=8u
RDP0_11 vdd ob0_11 10k
RDN0_11 vdd o0_11 10k
MT0_11 t0_11 g_VT0 0 0 NCH L=1u W=8u
COP0_11 o0_11 0 0.1f
COM0_11 ob0_11 0 0.1f

* column pair cp0_12/cn0_12: 16 four-quadrant synapses + bias row
MVA0_0_12P cp0_12 g_VA0_0_12 bp 0 NCH L=1u W=4u
MVB0_0_12P cp0_12 g_VB0_0_12 bm 0 NCH L=1u W=4u
MVB0_0_12N cn0_12 g_VB0_0_12 bp 0 NCH L=1u W=4u
MVA0_0_12N cn0_12 g_VA0_0_12 bm 0 NCH L=1u W=4u
MVA0_1_12P cp0_12 g_VA0_1_12 xp1 0 NCH L=1u W=4u
MVB0_1_12P cp0_12 g_VB0_1_12 xm1 0 NCH L=1u W=4u
MVB0_1_12N cn0_12 g_VB0_1_12 xp1 0 NCH L=1u W=4u
MVA0_1_12N cn0_12 g_VA0_1_12 xm1 0 NCH L=1u W=4u
MVA0_2_12P cp0_12 g_VA0_2_12 xp2 0 NCH L=1u W=4u
MVB0_2_12P cp0_12 g_VB0_2_12 xm2 0 NCH L=1u W=4u
MVB0_2_12N cn0_12 g_VB0_2_12 xp2 0 NCH L=1u W=4u
MVA0_2_12N cn0_12 g_VA0_2_12 xm2 0 NCH L=1u W=4u
MVA0_3_12P cp0_12 g_VA0_3_12 xp3 0 NCH L=1u W=4u
MVB0_3_12P cp0_12 g_VB0_3_12 xm3 0 NCH L=1u W=4u
MVB0_3_12N cn0_12 g_VB0_3_12 xp3 0 NCH L=1u W=4u
MVA0_3_12N cn0_12 g_VA0_3_12 xm3 0 NCH L=1u W=4u
MVA0_4_12P cp0_12 g_VA0_4_12 xp4 0 NCH L=1u W=4u
MVB0_4_12P cp0_12 g_VB0_4_12 xm4 0 NCH L=1u W=4u
MVB0_4_12N cn0_12 g_VB0_4_12 xp4 0 NCH L=1u W=4u
MVA0_4_12N cn0_12 g_VA0_4_12 xm4 0 NCH L=1u W=4u
MVA0_5_12P cp0_12 g_VA0_5_12 xp5 0 NCH L=1u W=4u
MVB0_5_12P cp0_12 g_VB0_5_12 xm5 0 NCH L=1u W=4u
MVB0_5_12N cn0_12 g_VB0_5_12 xp5 0 NCH L=1u W=4u
MVA0_5_12N cn0_12 g_VA0_5_12 xm5 0 NCH L=1u W=4u
MVA0_6_12P cp0_12 g_VA0_6_12 xp6 0 NCH L=1u W=4u
MVB0_6_12P cp0_12 g_VB0_6_12 xm6 0 NCH L=1u W=4u
MVB0_6_12N cn0_12 g_VB0_6_12 xp6 0 NCH L=1u W=4u
MVA0_6_12N cn0_12 g_VA0_6_12 xm6 0 NCH L=1u W=4u
MVA0_7_12P cp0_12 g_VA0_7_12 xp7 0 NCH L=1u W=4u
MVB0_7_12P cp0_12 g_VB0_7_12 xm7 0 NCH L=1u W=4u
MVB0_7_12N cn0_12 g_VB0_7_12 xp7 0 NCH L=1u W=4u
MVA0_7_12N cn0_12 g_VA0_7_12 xm7 0 NCH L=1u W=4u
MVA0_8_12P cp0_12 g_VA0_8_12 xp8 0 NCH L=1u W=4u
MVB0_8_12P cp0_12 g_VB0_8_12 xm8 0 NCH L=1u W=4u
MVB0_8_12N cn0_12 g_VB0_8_12 xp8 0 NCH L=1u W=4u
MVA0_8_12N cn0_12 g_VA0_8_12 xm8 0 NCH L=1u W=4u
MVA0_9_12P cp0_12 g_VA0_9_12 xp9 0 NCH L=1u W=4u
MVB0_9_12P cp0_12 g_VB0_9_12 xm9 0 NCH L=1u W=4u
MVB0_9_12N cn0_12 g_VB0_9_12 xp9 0 NCH L=1u W=4u
MVA0_9_12N cn0_12 g_VA0_9_12 xm9 0 NCH L=1u W=4u
MVA0_10_12P cp0_12 g_VA0_10_12 xp10 0 NCH L=1u W=4u
MVB0_10_12P cp0_12 g_VB0_10_12 xm10 0 NCH L=1u W=4u
MVB0_10_12N cn0_12 g_VB0_10_12 xp10 0 NCH L=1u W=4u
MVA0_10_12N cn0_12 g_VA0_10_12 xm10 0 NCH L=1u W=4u
MVA0_11_12P cp0_12 g_VA0_11_12 xp11 0 NCH L=1u W=4u
MVB0_11_12P cp0_12 g_VB0_11_12 xm11 0 NCH L=1u W=4u
MVB0_11_12N cn0_12 g_VB0_11_12 xp11 0 NCH L=1u W=4u
MVA0_11_12N cn0_12 g_VA0_11_12 xm11 0 NCH L=1u W=4u
MVA0_12_12P cp0_12 g_VA0_12_12 xp12 0 NCH L=1u W=4u
MVB0_12_12P cp0_12 g_VB0_12_12 xm12 0 NCH L=1u W=4u
MVB0_12_12N cn0_12 g_VB0_12_12 xp12 0 NCH L=1u W=4u
MVA0_12_12N cn0_12 g_VA0_12_12 xm12 0 NCH L=1u W=4u
MVA0_13_12P cp0_12 g_VA0_13_12 xp13 0 NCH L=1u W=4u
MVB0_13_12P cp0_12 g_VB0_13_12 xm13 0 NCH L=1u W=4u
MVB0_13_12N cn0_12 g_VB0_13_12 xp13 0 NCH L=1u W=4u
MVA0_13_12N cn0_12 g_VA0_13_12 xm13 0 NCH L=1u W=4u
MVA0_14_12P cp0_12 g_VA0_14_12 xp14 0 NCH L=1u W=4u
MVB0_14_12P cp0_12 g_VB0_14_12 xm14 0 NCH L=1u W=4u
MVB0_14_12N cn0_12 g_VB0_14_12 xp14 0 NCH L=1u W=4u
MVA0_14_12N cn0_12 g_VA0_14_12 xm14 0 NCH L=1u W=4u
MVA0_15_12P cp0_12 g_VA0_15_12 xp15 0 NCH L=1u W=4u
MVB0_15_12P cp0_12 g_VB0_15_12 xm15 0 NCH L=1u W=4u
MVB0_15_12N cn0_12 g_VB0_15_12 xp15 0 NCH L=1u W=4u
MVA0_15_12N cn0_12 g_VA0_15_12 xm15 0 NCH L=1u W=4u
MVA0_16_12P cp0_12 g_VA0_16_12 xp16 0 NCH L=1u W=4u
MVB0_16_12P cp0_12 g_VB0_16_12 xm16 0 NCH L=1u W=4u
MVB0_16_12N cn0_12 g_VB0_16_12 xp16 0 NCH L=1u W=4u
MVA0_16_12N cn0_12 g_VA0_16_12 xm16 0 NCH L=1u W=4u
RLP0_12 vdd cp0_12 3660
RLN0_12 vdd cn0_12 3660
CCP0_12 cp0_12 0 0.1f
CCN0_12 cn0_12 0 0.1f
MDP0_12 ob0_12 cp0_12 t0_12 0 NCH L=1u W=8u
MDN0_12 o0_12 cn0_12 t0_12 0 NCH L=1u W=8u
RDP0_12 vdd ob0_12 10k
RDN0_12 vdd o0_12 10k
MT0_12 t0_12 g_VT0 0 0 NCH L=1u W=8u
COP0_12 o0_12 0 0.1f
COM0_12 ob0_12 0 0.1f

* ===== layer 1: 12 -> 10 (four-quadrant) =====
* column pair cp1_1/cn1_1: 12 four-quadrant synapses + bias row
MVA1_0_1P cp1_1 g_VA1_0_1 bp 0 NCH L=1u W=4u
MVB1_0_1P cp1_1 g_VB1_0_1 bm 0 NCH L=1u W=4u
MVB1_0_1N cn1_1 g_VB1_0_1 bp 0 NCH L=1u W=4u
MVA1_0_1N cn1_1 g_VA1_0_1 bm 0 NCH L=1u W=4u
MVA1_1_1P cp1_1 g_VA1_1_1 o0_1 0 NCH L=1u W=4u
MVB1_1_1P cp1_1 g_VB1_1_1 ob0_1 0 NCH L=1u W=4u
MVB1_1_1N cn1_1 g_VB1_1_1 o0_1 0 NCH L=1u W=4u
MVA1_1_1N cn1_1 g_VA1_1_1 ob0_1 0 NCH L=1u W=4u
MVA1_2_1P cp1_1 g_VA1_2_1 o0_2 0 NCH L=1u W=4u
MVB1_2_1P cp1_1 g_VB1_2_1 ob0_2 0 NCH L=1u W=4u
MVB1_2_1N cn1_1 g_VB1_2_1 o0_2 0 NCH L=1u W=4u
MVA1_2_1N cn1_1 g_VA1_2_1 ob0_2 0 NCH L=1u W=4u
MVA1_3_1P cp1_1 g_VA1_3_1 o0_3 0 NCH L=1u W=4u
MVB1_3_1P cp1_1 g_VB1_3_1 ob0_3 0 NCH L=1u W=4u
MVB1_3_1N cn1_1 g_VB1_3_1 o0_3 0 NCH L=1u W=4u
MVA1_3_1N cn1_1 g_VA1_3_1 ob0_3 0 NCH L=1u W=4u
MVA1_4_1P cp1_1 g_VA1_4_1 o0_4 0 NCH L=1u W=4u
MVB1_4_1P cp1_1 g_VB1_4_1 ob0_4 0 NCH L=1u W=4u
MVB1_4_1N cn1_1 g_VB1_4_1 o0_4 0 NCH L=1u W=4u
MVA1_4_1N cn1_1 g_VA1_4_1 ob0_4 0 NCH L=1u W=4u
MVA1_5_1P cp1_1 g_VA1_5_1 o0_5 0 NCH L=1u W=4u
MVB1_5_1P cp1_1 g_VB1_5_1 ob0_5 0 NCH L=1u W=4u
MVB1_5_1N cn1_1 g_VB1_5_1 o0_5 0 NCH L=1u W=4u
MVA1_5_1N cn1_1 g_VA1_5_1 ob0_5 0 NCH L=1u W=4u
MVA1_6_1P cp1_1 g_VA1_6_1 o0_6 0 NCH L=1u W=4u
MVB1_6_1P cp1_1 g_VB1_6_1 ob0_6 0 NCH L=1u W=4u
MVB1_6_1N cn1_1 g_VB1_6_1 o0_6 0 NCH L=1u W=4u
MVA1_6_1N cn1_1 g_VA1_6_1 ob0_6 0 NCH L=1u W=4u
MVA1_7_1P cp1_1 g_VA1_7_1 o0_7 0 NCH L=1u W=4u
MVB1_7_1P cp1_1 g_VB1_7_1 ob0_7 0 NCH L=1u W=4u
MVB1_7_1N cn1_1 g_VB1_7_1 o0_7 0 NCH L=1u W=4u
MVA1_7_1N cn1_1 g_VA1_7_1 ob0_7 0 NCH L=1u W=4u
MVA1_8_1P cp1_1 g_VA1_8_1 o0_8 0 NCH L=1u W=4u
MVB1_8_1P cp1_1 g_VB1_8_1 ob0_8 0 NCH L=1u W=4u
MVB1_8_1N cn1_1 g_VB1_8_1 o0_8 0 NCH L=1u W=4u
MVA1_8_1N cn1_1 g_VA1_8_1 ob0_8 0 NCH L=1u W=4u
MVA1_9_1P cp1_1 g_VA1_9_1 o0_9 0 NCH L=1u W=4u
MVB1_9_1P cp1_1 g_VB1_9_1 ob0_9 0 NCH L=1u W=4u
MVB1_9_1N cn1_1 g_VB1_9_1 o0_9 0 NCH L=1u W=4u
MVA1_9_1N cn1_1 g_VA1_9_1 ob0_9 0 NCH L=1u W=4u
MVA1_10_1P cp1_1 g_VA1_10_1 o0_10 0 NCH L=1u W=4u
MVB1_10_1P cp1_1 g_VB1_10_1 ob0_10 0 NCH L=1u W=4u
MVB1_10_1N cn1_1 g_VB1_10_1 o0_10 0 NCH L=1u W=4u
MVA1_10_1N cn1_1 g_VA1_10_1 ob0_10 0 NCH L=1u W=4u
MVA1_11_1P cp1_1 g_VA1_11_1 o0_11 0 NCH L=1u W=4u
MVB1_11_1P cp1_1 g_VB1_11_1 ob0_11 0 NCH L=1u W=4u
MVB1_11_1N cn1_1 g_VB1_11_1 o0_11 0 NCH L=1u W=4u
MVA1_11_1N cn1_1 g_VA1_11_1 ob0_11 0 NCH L=1u W=4u
MVA1_12_1P cp1_1 g_VA1_12_1 o0_12 0 NCH L=1u W=4u
MVB1_12_1P cp1_1 g_VB1_12_1 ob0_12 0 NCH L=1u W=4u
MVB1_12_1N cn1_1 g_VB1_12_1 o0_12 0 NCH L=1u W=4u
MVA1_12_1N cn1_1 g_VA1_12_1 ob0_12 0 NCH L=1u W=4u
RLP1_1 vdd cp1_1 337
RLN1_1 vdd cn1_1 337
CCP1_1 cp1_1 0 0.1f
CCN1_1 cn1_1 0 0.1f
MDP1_1 ob1_1 cp1_1 t1_1 0 NCH L=1u W=8u
MDN1_1 o1_1 cn1_1 t1_1 0 NCH L=1u W=8u
RDP1_1 vdd ob1_1 10k
RDN1_1 vdd o1_1 10k
MT1_1 t1_1 g_VT1 0 0 NCH L=1u W=8u
COP1_1 o1_1 0 0.1f
COM1_1 ob1_1 0 0.1f

* column pair cp1_2/cn1_2: 12 four-quadrant synapses + bias row
MVA1_0_2P cp1_2 g_VA1_0_2 bp 0 NCH L=1u W=4u
MVB1_0_2P cp1_2 g_VB1_0_2 bm 0 NCH L=1u W=4u
MVB1_0_2N cn1_2 g_VB1_0_2 bp 0 NCH L=1u W=4u
MVA1_0_2N cn1_2 g_VA1_0_2 bm 0 NCH L=1u W=4u
MVA1_1_2P cp1_2 g_VA1_1_2 o0_1 0 NCH L=1u W=4u
MVB1_1_2P cp1_2 g_VB1_1_2 ob0_1 0 NCH L=1u W=4u
MVB1_1_2N cn1_2 g_VB1_1_2 o0_1 0 NCH L=1u W=4u
MVA1_1_2N cn1_2 g_VA1_1_2 ob0_1 0 NCH L=1u W=4u
MVA1_2_2P cp1_2 g_VA1_2_2 o0_2 0 NCH L=1u W=4u
MVB1_2_2P cp1_2 g_VB1_2_2 ob0_2 0 NCH L=1u W=4u
MVB1_2_2N cn1_2 g_VB1_2_2 o0_2 0 NCH L=1u W=4u
MVA1_2_2N cn1_2 g_VA1_2_2 ob0_2 0 NCH L=1u W=4u
MVA1_3_2P cp1_2 g_VA1_3_2 o0_3 0 NCH L=1u W=4u
MVB1_3_2P cp1_2 g_VB1_3_2 ob0_3 0 NCH L=1u W=4u
MVB1_3_2N cn1_2 g_VB1_3_2 o0_3 0 NCH L=1u W=4u
MVA1_3_2N cn1_2 g_VA1_3_2 ob0_3 0 NCH L=1u W=4u
MVA1_4_2P cp1_2 g_VA1_4_2 o0_4 0 NCH L=1u W=4u
MVB1_4_2P cp1_2 g_VB1_4_2 ob0_4 0 NCH L=1u W=4u
MVB1_4_2N cn1_2 g_VB1_4_2 o0_4 0 NCH L=1u W=4u
MVA1_4_2N cn1_2 g_VA1_4_2 ob0_4 0 NCH L=1u W=4u
MVA1_5_2P cp1_2 g_VA1_5_2 o0_5 0 NCH L=1u W=4u
MVB1_5_2P cp1_2 g_VB1_5_2 ob0_5 0 NCH L=1u W=4u
MVB1_5_2N cn1_2 g_VB1_5_2 o0_5 0 NCH L=1u W=4u
MVA1_5_2N cn1_2 g_VA1_5_2 ob0_5 0 NCH L=1u W=4u
MVA1_6_2P cp1_2 g_VA1_6_2 o0_6 0 NCH L=1u W=4u
MVB1_6_2P cp1_2 g_VB1_6_2 ob0_6 0 NCH L=1u W=4u
MVB1_6_2N cn1_2 g_VB1_6_2 o0_6 0 NCH L=1u W=4u
MVA1_6_2N cn1_2 g_VA1_6_2 ob0_6 0 NCH L=1u W=4u
MVA1_7_2P cp1_2 g_VA1_7_2 o0_7 0 NCH L=1u W=4u
MVB1_7_2P cp1_2 g_VB1_7_2 ob0_7 0 NCH L=1u W=4u
MVB1_7_2N cn1_2 g_VB1_7_2 o0_7 0 NCH L=1u W=4u
MVA1_7_2N cn1_2 g_VA1_7_2 ob0_7 0 NCH L=1u W=4u
MVA1_8_2P cp1_2 g_VA1_8_2 o0_8 0 NCH L=1u W=4u
MVB1_8_2P cp1_2 g_VB1_8_2 ob0_8 0 NCH L=1u W=4u
MVB1_8_2N cn1_2 g_VB1_8_2 o0_8 0 NCH L=1u W=4u
MVA1_8_2N cn1_2 g_VA1_8_2 ob0_8 0 NCH L=1u W=4u
MVA1_9_2P cp1_2 g_VA1_9_2 o0_9 0 NCH L=1u W=4u
MVB1_9_2P cp1_2 g_VB1_9_2 ob0_9 0 NCH L=1u W=4u
MVB1_9_2N cn1_2 g_VB1_9_2 o0_9 0 NCH L=1u W=4u
MVA1_9_2N cn1_2 g_VA1_9_2 ob0_9 0 NCH L=1u W=4u
MVA1_10_2P cp1_2 g_VA1_10_2 o0_10 0 NCH L=1u W=4u
MVB1_10_2P cp1_2 g_VB1_10_2 ob0_10 0 NCH L=1u W=4u
MVB1_10_2N cn1_2 g_VB1_10_2 o0_10 0 NCH L=1u W=4u
MVA1_10_2N cn1_2 g_VA1_10_2 ob0_10 0 NCH L=1u W=4u
MVA1_11_2P cp1_2 g_VA1_11_2 o0_11 0 NCH L=1u W=4u
MVB1_11_2P cp1_2 g_VB1_11_2 ob0_11 0 NCH L=1u W=4u
MVB1_11_2N cn1_2 g_VB1_11_2 o0_11 0 NCH L=1u W=4u
MVA1_11_2N cn1_2 g_VA1_11_2 ob0_11 0 NCH L=1u W=4u
MVA1_12_2P cp1_2 g_VA1_12_2 o0_12 0 NCH L=1u W=4u
MVB1_12_2P cp1_2 g_VB1_12_2 ob0_12 0 NCH L=1u W=4u
MVB1_12_2N cn1_2 g_VB1_12_2 o0_12 0 NCH L=1u W=4u
MVA1_12_2N cn1_2 g_VA1_12_2 ob0_12 0 NCH L=1u W=4u
RLP1_2 vdd cp1_2 337
RLN1_2 vdd cn1_2 337
CCP1_2 cp1_2 0 0.1f
CCN1_2 cn1_2 0 0.1f
MDP1_2 ob1_2 cp1_2 t1_2 0 NCH L=1u W=8u
MDN1_2 o1_2 cn1_2 t1_2 0 NCH L=1u W=8u
RDP1_2 vdd ob1_2 10k
RDN1_2 vdd o1_2 10k
MT1_2 t1_2 g_VT1 0 0 NCH L=1u W=8u
COP1_2 o1_2 0 0.1f
COM1_2 ob1_2 0 0.1f

* column pair cp1_3/cn1_3: 12 four-quadrant synapses + bias row
MVA1_0_3P cp1_3 g_VA1_0_3 bp 0 NCH L=1u W=4u
MVB1_0_3P cp1_3 g_VB1_0_3 bm 0 NCH L=1u W=4u
MVB1_0_3N cn1_3 g_VB1_0_3 bp 0 NCH L=1u W=4u
MVA1_0_3N cn1_3 g_VA1_0_3 bm 0 NCH L=1u W=4u
MVA1_1_3P cp1_3 g_VA1_1_3 o0_1 0 NCH L=1u W=4u
MVB1_1_3P cp1_3 g_VB1_1_3 ob0_1 0 NCH L=1u W=4u
MVB1_1_3N cn1_3 g_VB1_1_3 o0_1 0 NCH L=1u W=4u
MVA1_1_3N cn1_3 g_VA1_1_3 ob0_1 0 NCH L=1u W=4u
MVA1_2_3P cp1_3 g_VA1_2_3 o0_2 0 NCH L=1u W=4u
MVB1_2_3P cp1_3 g_VB1_2_3 ob0_2 0 NCH L=1u W=4u
MVB1_2_3N cn1_3 g_VB1_2_3 o0_2 0 NCH L=1u W=4u
MVA1_2_3N cn1_3 g_VA1_2_3 ob0_2 0 NCH L=1u W=4u
MVA1_3_3P cp1_3 g_VA1_3_3 o0_3 0 NCH L=1u W=4u
MVB1_3_3P cp1_3 g_VB1_3_3 ob0_3 0 NCH L=1u W=4u
MVB1_3_3N cn1_3 g_VB1_3_3 o0_3 0 NCH L=1u W=4u
MVA1_3_3N cn1_3 g_VA1_3_3 ob0_3 0 NCH L=1u W=4u
MVA1_4_3P cp1_3 g_VA1_4_3 o0_4 0 NCH L=1u W=4u
MVB1_4_3P cp1_3 g_VB1_4_3 ob0_4 0 NCH L=1u W=4u
MVB1_4_3N cn1_3 g_VB1_4_3 o0_4 0 NCH L=1u W=4u
MVA1_4_3N cn1_3 g_VA1_4_3 ob0_4 0 NCH L=1u W=4u
MVA1_5_3P cp1_3 g_VA1_5_3 o0_5 0 NCH L=1u W=4u
MVB1_5_3P cp1_3 g_VB1_5_3 ob0_5 0 NCH L=1u W=4u
MVB1_5_3N cn1_3 g_VB1_5_3 o0_5 0 NCH L=1u W=4u
MVA1_5_3N cn1_3 g_VA1_5_3 ob0_5 0 NCH L=1u W=4u
MVA1_6_3P cp1_3 g_VA1_6_3 o0_6 0 NCH L=1u W=4u
MVB1_6_3P cp1_3 g_VB1_6_3 ob0_6 0 NCH L=1u W=4u
MVB1_6_3N cn1_3 g_VB1_6_3 o0_6 0 NCH L=1u W=4u
MVA1_6_3N cn1_3 g_VA1_6_3 ob0_6 0 NCH L=1u W=4u
MVA1_7_3P cp1_3 g_VA1_7_3 o0_7 0 NCH L=1u W=4u
MVB1_7_3P cp1_3 g_VB1_7_3 ob0_7 0 NCH L=1u W=4u
MVB1_7_3N cn1_3 g_VB1_7_3 o0_7 0 NCH L=1u W=4u
MVA1_7_3N cn1_3 g_VA1_7_3 ob0_7 0 NCH L=1u W=4u
MVA1_8_3P cp1_3 g_VA1_8_3 o0_8 0 NCH L=1u W=4u
MVB1_8_3P cp1_3 g_VB1_8_3 ob0_8 0 NCH L=1u W=4u
MVB1_8_3N cn1_3 g_VB1_8_3 o0_8 0 NCH L=1u W=4u
MVA1_8_3N cn1_3 g_VA1_8_3 ob0_8 0 NCH L=1u W=4u
MVA1_9_3P cp1_3 g_VA1_9_3 o0_9 0 NCH L=1u W=4u
MVB1_9_3P cp1_3 g_VB1_9_3 ob0_9 0 NCH L=1u W=4u
MVB1_9_3N cn1_3 g_VB1_9_3 o0_9 0 NCH L=1u W=4u
MVA1_9_3N cn1_3 g_VA1_9_3 ob0_9 0 NCH L=1u W=4u
MVA1_10_3P cp1_3 g_VA1_10_3 o0_10 0 NCH L=1u W=4u
MVB1_10_3P cp1_3 g_VB1_10_3 ob0_10 0 NCH L=1u W=4u
MVB1_10_3N cn1_3 g_VB1_10_3 o0_10 0 NCH L=1u W=4u
MVA1_10_3N cn1_3 g_VA1_10_3 ob0_10 0 NCH L=1u W=4u
MVA1_11_3P cp1_3 g_VA1_11_3 o0_11 0 NCH L=1u W=4u
MVB1_11_3P cp1_3 g_VB1_11_3 ob0_11 0 NCH L=1u W=4u
MVB1_11_3N cn1_3 g_VB1_11_3 o0_11 0 NCH L=1u W=4u
MVA1_11_3N cn1_3 g_VA1_11_3 ob0_11 0 NCH L=1u W=4u
MVA1_12_3P cp1_3 g_VA1_12_3 o0_12 0 NCH L=1u W=4u
MVB1_12_3P cp1_3 g_VB1_12_3 ob0_12 0 NCH L=1u W=4u
MVB1_12_3N cn1_3 g_VB1_12_3 o0_12 0 NCH L=1u W=4u
MVA1_12_3N cn1_3 g_VA1_12_3 ob0_12 0 NCH L=1u W=4u
RLP1_3 vdd cp1_3 337
RLN1_3 vdd cn1_3 337
CCP1_3 cp1_3 0 0.1f
CCN1_3 cn1_3 0 0.1f
MDP1_3 ob1_3 cp1_3 t1_3 0 NCH L=1u W=8u
MDN1_3 o1_3 cn1_3 t1_3 0 NCH L=1u W=8u
RDP1_3 vdd ob1_3 10k
RDN1_3 vdd o1_3 10k
MT1_3 t1_3 g_VT1 0 0 NCH L=1u W=8u
COP1_3 o1_3 0 0.1f
COM1_3 ob1_3 0 0.1f

* column pair cp1_4/cn1_4: 12 four-quadrant synapses + bias row
MVA1_0_4P cp1_4 g_VA1_0_4 bp 0 NCH L=1u W=4u
MVB1_0_4P cp1_4 g_VB1_0_4 bm 0 NCH L=1u W=4u
MVB1_0_4N cn1_4 g_VB1_0_4 bp 0 NCH L=1u W=4u
MVA1_0_4N cn1_4 g_VA1_0_4 bm 0 NCH L=1u W=4u
MVA1_1_4P cp1_4 g_VA1_1_4 o0_1 0 NCH L=1u W=4u
MVB1_1_4P cp1_4 g_VB1_1_4 ob0_1 0 NCH L=1u W=4u
MVB1_1_4N cn1_4 g_VB1_1_4 o0_1 0 NCH L=1u W=4u
MVA1_1_4N cn1_4 g_VA1_1_4 ob0_1 0 NCH L=1u W=4u
MVA1_2_4P cp1_4 g_VA1_2_4 o0_2 0 NCH L=1u W=4u
MVB1_2_4P cp1_4 g_VB1_2_4 ob0_2 0 NCH L=1u W=4u
MVB1_2_4N cn1_4 g_VB1_2_4 o0_2 0 NCH L=1u W=4u
MVA1_2_4N cn1_4 g_VA1_2_4 ob0_2 0 NCH L=1u W=4u
MVA1_3_4P cp1_4 g_VA1_3_4 o0_3 0 NCH L=1u W=4u
MVB1_3_4P cp1_4 g_VB1_3_4 ob0_3 0 NCH L=1u W=4u
MVB1_3_4N cn1_4 g_VB1_3_4 o0_3 0 NCH L=1u W=4u
MVA1_3_4N cn1_4 g_VA1_3_4 ob0_3 0 NCH L=1u W=4u
MVA1_4_4P cp1_4 g_VA1_4_4 o0_4 0 NCH L=1u W=4u
MVB1_4_4P cp1_4 g_VB1_4_4 ob0_4 0 NCH L=1u W=4u
MVB1_4_4N cn1_4 g_VB1_4_4 o0_4 0 NCH L=1u W=4u
MVA1_4_4N cn1_4 g_VA1_4_4 ob0_4 0 NCH L=1u W=4u
MVA1_5_4P cp1_4 g_VA1_5_4 o0_5 0 NCH L=1u W=4u
MVB1_5_4P cp1_4 g_VB1_5_4 ob0_5 0 NCH L=1u W=4u
MVB1_5_4N cn1_4 g_VB1_5_4 o0_5 0 NCH L=1u W=4u
MVA1_5_4N cn1_4 g_VA1_5_4 ob0_5 0 NCH L=1u W=4u
MVA1_6_4P cp1_4 g_VA1_6_4 o0_6 0 NCH L=1u W=4u
MVB1_6_4P cp1_4 g_VB1_6_4 ob0_6 0 NCH L=1u W=4u
MVB1_6_4N cn1_4 g_VB1_6_4 o0_6 0 NCH L=1u W=4u
MVA1_6_4N cn1_4 g_VA1_6_4 ob0_6 0 NCH L=1u W=4u
MVA1_7_4P cp1_4 g_VA1_7_4 o0_7 0 NCH L=1u W=4u
MVB1_7_4P cp1_4 g_VB1_7_4 ob0_7 0 NCH L=1u W=4u
MVB1_7_4N cn1_4 g_VB1_7_4 o0_7 0 NCH L=1u W=4u
MVA1_7_4N cn1_4 g_VA1_7_4 ob0_7 0 NCH L=1u W=4u
MVA1_8_4P cp1_4 g_VA1_8_4 o0_8 0 NCH L=1u W=4u
MVB1_8_4P cp1_4 g_VB1_8_4 ob0_8 0 NCH L=1u W=4u
MVB1_8_4N cn1_4 g_VB1_8_4 o0_8 0 NCH L=1u W=4u
MVA1_8_4N cn1_4 g_VA1_8_4 ob0_8 0 NCH L=1u W=4u
MVA1_9_4P cp1_4 g_VA1_9_4 o0_9 0 NCH L=1u W=4u
MVB1_9_4P cp1_4 g_VB1_9_4 ob0_9 0 NCH L=1u W=4u
MVB1_9_4N cn1_4 g_VB1_9_4 o0_9 0 NCH L=1u W=4u
MVA1_9_4N cn1_4 g_VA1_9_4 ob0_9 0 NCH L=1u W=4u
MVA1_10_4P cp1_4 g_VA1_10_4 o0_10 0 NCH L=1u W=4u
MVB1_10_4P cp1_4 g_VB1_10_4 ob0_10 0 NCH L=1u W=4u
MVB1_10_4N cn1_4 g_VB1_10_4 o0_10 0 NCH L=1u W=4u
MVA1_10_4N cn1_4 g_VA1_10_4 ob0_10 0 NCH L=1u W=4u
MVA1_11_4P cp1_4 g_VA1_11_4 o0_11 0 NCH L=1u W=4u
MVB1_11_4P cp1_4 g_VB1_11_4 ob0_11 0 NCH L=1u W=4u
MVB1_11_4N cn1_4 g_VB1_11_4 o0_11 0 NCH L=1u W=4u
MVA1_11_4N cn1_4 g_VA1_11_4 ob0_11 0 NCH L=1u W=4u
MVA1_12_4P cp1_4 g_VA1_12_4 o0_12 0 NCH L=1u W=4u
MVB1_12_4P cp1_4 g_VB1_12_4 ob0_12 0 NCH L=1u W=4u
MVB1_12_4N cn1_4 g_VB1_12_4 o0_12 0 NCH L=1u W=4u
MVA1_12_4N cn1_4 g_VA1_12_4 ob0_12 0 NCH L=1u W=4u
RLP1_4 vdd cp1_4 337
RLN1_4 vdd cn1_4 337
CCP1_4 cp1_4 0 0.1f
CCN1_4 cn1_4 0 0.1f
MDP1_4 ob1_4 cp1_4 t1_4 0 NCH L=1u W=8u
MDN1_4 o1_4 cn1_4 t1_4 0 NCH L=1u W=8u
RDP1_4 vdd ob1_4 10k
RDN1_4 vdd o1_4 10k
MT1_4 t1_4 g_VT1 0 0 NCH L=1u W=8u
COP1_4 o1_4 0 0.1f
COM1_4 ob1_4 0 0.1f

* column pair cp1_5/cn1_5: 12 four-quadrant synapses + bias row
MVA1_0_5P cp1_5 g_VA1_0_5 bp 0 NCH L=1u W=4u
MVB1_0_5P cp1_5 g_VB1_0_5 bm 0 NCH L=1u W=4u
MVB1_0_5N cn1_5 g_VB1_0_5 bp 0 NCH L=1u W=4u
MVA1_0_5N cn1_5 g_VA1_0_5 bm 0 NCH L=1u W=4u
MVA1_1_5P cp1_5 g_VA1_1_5 o0_1 0 NCH L=1u W=4u
MVB1_1_5P cp1_5 g_VB1_1_5 ob0_1 0 NCH L=1u W=4u
MVB1_1_5N cn1_5 g_VB1_1_5 o0_1 0 NCH L=1u W=4u
MVA1_1_5N cn1_5 g_VA1_1_5 ob0_1 0 NCH L=1u W=4u
MVA1_2_5P cp1_5 g_VA1_2_5 o0_2 0 NCH L=1u W=4u
MVB1_2_5P cp1_5 g_VB1_2_5 ob0_2 0 NCH L=1u W=4u
MVB1_2_5N cn1_5 g_VB1_2_5 o0_2 0 NCH L=1u W=4u
MVA1_2_5N cn1_5 g_VA1_2_5 ob0_2 0 NCH L=1u W=4u
MVA1_3_5P cp1_5 g_VA1_3_5 o0_3 0 NCH L=1u W=4u
MVB1_3_5P cp1_5 g_VB1_3_5 ob0_3 0 NCH L=1u W=4u
MVB1_3_5N cn1_5 g_VB1_3_5 o0_3 0 NCH L=1u W=4u
MVA1_3_5N cn1_5 g_VA1_3_5 ob0_3 0 NCH L=1u W=4u
MVA1_4_5P cp1_5 g_VA1_4_5 o0_4 0 NCH L=1u W=4u
MVB1_4_5P cp1_5 g_VB1_4_5 ob0_4 0 NCH L=1u W=4u
MVB1_4_5N cn1_5 g_VB1_4_5 o0_4 0 NCH L=1u W=4u
MVA1_4_5N cn1_5 g_VA1_4_5 ob0_4 0 NCH L=1u W=4u
MVA1_5_5P cp1_5 g_VA1_5_5 o0_5 0 NCH L=1u W=4u
MVB1_5_5P cp1_5 g_VB1_5_5 ob0_5 0 NCH L=1u W=4u
MVB1_5_5N cn1_5 g_VB1_5_5 o0_5 0 NCH L=1u W=4u
MVA1_5_5N cn1_5 g_VA1_5_5 ob0_5 0 NCH L=1u W=4u
MVA1_6_5P cp1_5 g_VA1_6_5 o0_6 0 NCH L=1u W=4u
MVB1_6_5P cp1_5 g_VB1_6_5 ob0_6 0 NCH L=1u W=4u
MVB1_6_5N cn1_5 g_VB1_6_5 o0_6 0 NCH L=1u W=4u
MVA1_6_5N cn1_5 g_VA1_6_5 ob0_6 0 NCH L=1u W=4u
MVA1_7_5P cp1_5 g_VA1_7_5 o0_7 0 NCH L=1u W=4u
MVB1_7_5P cp1_5 g_VB1_7_5 ob0_7 0 NCH L=1u W=4u
MVB1_7_5N cn1_5 g_VB1_7_5 o0_7 0 NCH L=1u W=4u
MVA1_7_5N cn1_5 g_VA1_7_5 ob0_7 0 NCH L=1u W=4u
MVA1_8_5P cp1_5 g_VA1_8_5 o0_8 0 NCH L=1u W=4u
MVB1_8_5P cp1_5 g_VB1_8_5 ob0_8 0 NCH L=1u W=4u
MVB1_8_5N cn1_5 g_VB1_8_5 o0_8 0 NCH L=1u W=4u
MVA1_8_5N cn1_5 g_VA1_8_5 ob0_8 0 NCH L=1u W=4u
MVA1_9_5P cp1_5 g_VA1_9_5 o0_9 0 NCH L=1u W=4u
MVB1_9_5P cp1_5 g_VB1_9_5 ob0_9 0 NCH L=1u W=4u
MVB1_9_5N cn1_5 g_VB1_9_5 o0_9 0 NCH L=1u W=4u
MVA1_9_5N cn1_5 g_VA1_9_5 ob0_9 0 NCH L=1u W=4u
MVA1_10_5P cp1_5 g_VA1_10_5 o0_10 0 NCH L=1u W=4u
MVB1_10_5P cp1_5 g_VB1_10_5 ob0_10 0 NCH L=1u W=4u
MVB1_10_5N cn1_5 g_VB1_10_5 o0_10 0 NCH L=1u W=4u
MVA1_10_5N cn1_5 g_VA1_10_5 ob0_10 0 NCH L=1u W=4u
MVA1_11_5P cp1_5 g_VA1_11_5 o0_11 0 NCH L=1u W=4u
MVB1_11_5P cp1_5 g_VB1_11_5 ob0_11 0 NCH L=1u W=4u
MVB1_11_5N cn1_5 g_VB1_11_5 o0_11 0 NCH L=1u W=4u
MVA1_11_5N cn1_5 g_VA1_11_5 ob0_11 0 NCH L=1u W=4u
MVA1_12_5P cp1_5 g_VA1_12_5 o0_12 0 NCH L=1u W=4u
MVB1_12_5P cp1_5 g_VB1_12_5 ob0_12 0 NCH L=1u W=4u
MVB1_12_5N cn1_5 g_VB1_12_5 o0_12 0 NCH L=1u W=4u
MVA1_12_5N cn1_5 g_VA1_12_5 ob0_12 0 NCH L=1u W=4u
RLP1_5 vdd cp1_5 337
RLN1_5 vdd cn1_5 337
CCP1_5 cp1_5 0 0.1f
CCN1_5 cn1_5 0 0.1f
MDP1_5 ob1_5 cp1_5 t1_5 0 NCH L=1u W=8u
MDN1_5 o1_5 cn1_5 t1_5 0 NCH L=1u W=8u
RDP1_5 vdd ob1_5 10k
RDN1_5 vdd o1_5 10k
MT1_5 t1_5 g_VT1 0 0 NCH L=1u W=8u
COP1_5 o1_5 0 0.1f
COM1_5 ob1_5 0 0.1f

* column pair cp1_6/cn1_6: 12 four-quadrant synapses + bias row
MVA1_0_6P cp1_6 g_VA1_0_6 bp 0 NCH L=1u W=4u
MVB1_0_6P cp1_6 g_VB1_0_6 bm 0 NCH L=1u W=4u
MVB1_0_6N cn1_6 g_VB1_0_6 bp 0 NCH L=1u W=4u
MVA1_0_6N cn1_6 g_VA1_0_6 bm 0 NCH L=1u W=4u
MVA1_1_6P cp1_6 g_VA1_1_6 o0_1 0 NCH L=1u W=4u
MVB1_1_6P cp1_6 g_VB1_1_6 ob0_1 0 NCH L=1u W=4u
MVB1_1_6N cn1_6 g_VB1_1_6 o0_1 0 NCH L=1u W=4u
MVA1_1_6N cn1_6 g_VA1_1_6 ob0_1 0 NCH L=1u W=4u
MVA1_2_6P cp1_6 g_VA1_2_6 o0_2 0 NCH L=1u W=4u
MVB1_2_6P cp1_6 g_VB1_2_6 ob0_2 0 NCH L=1u W=4u
MVB1_2_6N cn1_6 g_VB1_2_6 o0_2 0 NCH L=1u W=4u
MVA1_2_6N cn1_6 g_VA1_2_6 ob0_2 0 NCH L=1u W=4u
MVA1_3_6P cp1_6 g_VA1_3_6 o0_3 0 NCH L=1u W=4u
MVB1_3_6P cp1_6 g_VB1_3_6 ob0_3 0 NCH L=1u W=4u
MVB1_3_6N cn1_6 g_VB1_3_6 o0_3 0 NCH L=1u W=4u
MVA1_3_6N cn1_6 g_VA1_3_6 ob0_3 0 NCH L=1u W=4u
MVA1_4_6P cp1_6 g_VA1_4_6 o0_4 0 NCH L=1u W=4u
MVB1_4_6P cp1_6 g_VB1_4_6 ob0_4 0 NCH L=1u W=4u
MVB1_4_6N cn1_6 g_VB1_4_6 o0_4 0 NCH L=1u W=4u
MVA1_4_6N cn1_6 g_VA1_4_6 ob0_4 0 NCH L=1u W=4u
MVA1_5_6P cp1_6 g_VA1_5_6 o0_5 0 NCH L=1u W=4u
MVB1_5_6P cp1_6 g_VB1_5_6 ob0_5 0 NCH L=1u W=4u
MVB1_5_6N cn1_6 g_VB1_5_6 o0_5 0 NCH L=1u W=4u
MVA1_5_6N cn1_6 g_VA1_5_6 ob0_5 0 NCH L=1u W=4u
MVA1_6_6P cp1_6 g_VA1_6_6 o0_6 0 NCH L=1u W=4u
MVB1_6_6P cp1_6 g_VB1_6_6 ob0_6 0 NCH L=1u W=4u
MVB1_6_6N cn1_6 g_VB1_6_6 o0_6 0 NCH L=1u W=4u
MVA1_6_6N cn1_6 g_VA1_6_6 ob0_6 0 NCH L=1u W=4u
MVA1_7_6P cp1_6 g_VA1_7_6 o0_7 0 NCH L=1u W=4u
MVB1_7_6P cp1_6 g_VB1_7_6 ob0_7 0 NCH L=1u W=4u
MVB1_7_6N cn1_6 g_VB1_7_6 o0_7 0 NCH L=1u W=4u
MVA1_7_6N cn1_6 g_VA1_7_6 ob0_7 0 NCH L=1u W=4u
MVA1_8_6P cp1_6 g_VA1_8_6 o0_8 0 NCH L=1u W=4u
MVB1_8_6P cp1_6 g_VB1_8_6 ob0_8 0 NCH L=1u W=4u
MVB1_8_6N cn1_6 g_VB1_8_6 o0_8 0 NCH L=1u W=4u
MVA1_8_6N cn1_6 g_VA1_8_6 ob0_8 0 NCH L=1u W=4u
MVA1_9_6P cp1_6 g_VA1_9_6 o0_9 0 NCH L=1u W=4u
MVB1_9_6P cp1_6 g_VB1_9_6 ob0_9 0 NCH L=1u W=4u
MVB1_9_6N cn1_6 g_VB1_9_6 o0_9 0 NCH L=1u W=4u
MVA1_9_6N cn1_6 g_VA1_9_6 ob0_9 0 NCH L=1u W=4u
MVA1_10_6P cp1_6 g_VA1_10_6 o0_10 0 NCH L=1u W=4u
MVB1_10_6P cp1_6 g_VB1_10_6 ob0_10 0 NCH L=1u W=4u
MVB1_10_6N cn1_6 g_VB1_10_6 o0_10 0 NCH L=1u W=4u
MVA1_10_6N cn1_6 g_VA1_10_6 ob0_10 0 NCH L=1u W=4u
MVA1_11_6P cp1_6 g_VA1_11_6 o0_11 0 NCH L=1u W=4u
MVB1_11_6P cp1_6 g_VB1_11_6 ob0_11 0 NCH L=1u W=4u
MVB1_11_6N cn1_6 g_VB1_11_6 o0_11 0 NCH L=1u W=4u
MVA1_11_6N cn1_6 g_VA1_11_6 ob0_11 0 NCH L=1u W=4u
MVA1_12_6P cp1_6 g_VA1_12_6 o0_12 0 NCH L=1u W=4u
MVB1_12_6P cp1_6 g_VB1_12_6 ob0_12 0 NCH L=1u W=4u
MVB1_12_6N cn1_6 g_VB1_12_6 o0_12 0 NCH L=1u W=4u
MVA1_12_6N cn1_6 g_VA1_12_6 ob0_12 0 NCH L=1u W=4u
RLP1_6 vdd cp1_6 337
RLN1_6 vdd cn1_6 337
CCP1_6 cp1_6 0 0.1f
CCN1_6 cn1_6 0 0.1f
MDP1_6 ob1_6 cp1_6 t1_6 0 NCH L=1u W=8u
MDN1_6 o1_6 cn1_6 t1_6 0 NCH L=1u W=8u
RDP1_6 vdd ob1_6 10k
RDN1_6 vdd o1_6 10k
MT1_6 t1_6 g_VT1 0 0 NCH L=1u W=8u
COP1_6 o1_6 0 0.1f
COM1_6 ob1_6 0 0.1f

* column pair cp1_7/cn1_7: 12 four-quadrant synapses + bias row
MVA1_0_7P cp1_7 g_VA1_0_7 bp 0 NCH L=1u W=4u
MVB1_0_7P cp1_7 g_VB1_0_7 bm 0 NCH L=1u W=4u
MVB1_0_7N cn1_7 g_VB1_0_7 bp 0 NCH L=1u W=4u
MVA1_0_7N cn1_7 g_VA1_0_7 bm 0 NCH L=1u W=4u
MVA1_1_7P cp1_7 g_VA1_1_7 o0_1 0 NCH L=1u W=4u
MVB1_1_7P cp1_7 g_VB1_1_7 ob0_1 0 NCH L=1u W=4u
MVB1_1_7N cn1_7 g_VB1_1_7 o0_1 0 NCH L=1u W=4u
MVA1_1_7N cn1_7 g_VA1_1_7 ob0_1 0 NCH L=1u W=4u
MVA1_2_7P cp1_7 g_VA1_2_7 o0_2 0 NCH L=1u W=4u
MVB1_2_7P cp1_7 g_VB1_2_7 ob0_2 0 NCH L=1u W=4u
MVB1_2_7N cn1_7 g_VB1_2_7 o0_2 0 NCH L=1u W=4u
MVA1_2_7N cn1_7 g_VA1_2_7 ob0_2 0 NCH L=1u W=4u
MVA1_3_7P cp1_7 g_VA1_3_7 o0_3 0 NCH L=1u W=4u
MVB1_3_7P cp1_7 g_VB1_3_7 ob0_3 0 NCH L=1u W=4u
MVB1_3_7N cn1_7 g_VB1_3_7 o0_3 0 NCH L=1u W=4u
MVA1_3_7N cn1_7 g_VA1_3_7 ob0_3 0 NCH L=1u W=4u
MVA1_4_7P cp1_7 g_VA1_4_7 o0_4 0 NCH L=1u W=4u
MVB1_4_7P cp1_7 g_VB1_4_7 ob0_4 0 NCH L=1u W=4u
MVB1_4_7N cn1_7 g_VB1_4_7 o0_4 0 NCH L=1u W=4u
MVA1_4_7N cn1_7 g_VA1_4_7 ob0_4 0 NCH L=1u W=4u
MVA1_5_7P cp1_7 g_VA1_5_7 o0_5 0 NCH L=1u W=4u
MVB1_5_7P cp1_7 g_VB1_5_7 ob0_5 0 NCH L=1u W=4u
MVB1_5_7N cn1_7 g_VB1_5_7 o0_5 0 NCH L=1u W=4u
MVA1_5_7N cn1_7 g_VA1_5_7 ob0_5 0 NCH L=1u W=4u
MVA1_6_7P cp1_7 g_VA1_6_7 o0_6 0 NCH L=1u W=4u
MVB1_6_7P cp1_7 g_VB1_6_7 ob0_6 0 NCH L=1u W=4u
MVB1_6_7N cn1_7 g_VB1_6_7 o0_6 0 NCH L=1u W=4u
MVA1_6_7N cn1_7 g_VA1_6_7 ob0_6 0 NCH L=1u W=4u
MVA1_7_7P cp1_7 g_VA1_7_7 o0_7 0 NCH L=1u W=4u
MVB1_7_7P cp1_7 g_VB1_7_7 ob0_7 0 NCH L=1u W=4u
MVB1_7_7N cn1_7 g_VB1_7_7 o0_7 0 NCH L=1u W=4u
MVA1_7_7N cn1_7 g_VA1_7_7 ob0_7 0 NCH L=1u W=4u
MVA1_8_7P cp1_7 g_VA1_8_7 o0_8 0 NCH L=1u W=4u
MVB1_8_7P cp1_7 g_VB1_8_7 ob0_8 0 NCH L=1u W=4u
MVB1_8_7N cn1_7 g_VB1_8_7 o0_8 0 NCH L=1u W=4u
MVA1_8_7N cn1_7 g_VA1_8_7 ob0_8 0 NCH L=1u W=4u
MVA1_9_7P cp1_7 g_VA1_9_7 o0_9 0 NCH L=1u W=4u
MVB1_9_7P cp1_7 g_VB1_9_7 ob0_9 0 NCH L=1u W=4u
MVB1_9_7N cn1_7 g_VB1_9_7 o0_9 0 NCH L=1u W=4u
MVA1_9_7N cn1_7 g_VA1_9_7 ob0_9 0 NCH L=1u W=4u
MVA1_10_7P cp1_7 g_VA1_10_7 o0_10 0 NCH L=1u W=4u
MVB1_10_7P cp1_7 g_VB1_10_7 ob0_10 0 NCH L=1u W=4u
MVB1_10_7N cn1_7 g_VB1_10_7 o0_10 0 NCH L=1u W=4u
MVA1_10_7N cn1_7 g_VA1_10_7 ob0_10 0 NCH L=1u W=4u
MVA1_11_7P cp1_7 g_VA1_11_7 o0_11 0 NCH L=1u W=4u
MVB1_11_7P cp1_7 g_VB1_11_7 ob0_11 0 NCH L=1u W=4u
MVB1_11_7N cn1_7 g_VB1_11_7 o0_11 0 NCH L=1u W=4u
MVA1_11_7N cn1_7 g_VA1_11_7 ob0_11 0 NCH L=1u W=4u
MVA1_12_7P cp1_7 g_VA1_12_7 o0_12 0 NCH L=1u W=4u
MVB1_12_7P cp1_7 g_VB1_12_7 ob0_12 0 NCH L=1u W=4u
MVB1_12_7N cn1_7 g_VB1_12_7 o0_12 0 NCH L=1u W=4u
MVA1_12_7N cn1_7 g_VA1_12_7 ob0_12 0 NCH L=1u W=4u
RLP1_7 vdd cp1_7 337
RLN1_7 vdd cn1_7 337
CCP1_7 cp1_7 0 0.1f
CCN1_7 cn1_7 0 0.1f
MDP1_7 ob1_7 cp1_7 t1_7 0 NCH L=1u W=8u
MDN1_7 o1_7 cn1_7 t1_7 0 NCH L=1u W=8u
RDP1_7 vdd ob1_7 10k
RDN1_7 vdd o1_7 10k
MT1_7 t1_7 g_VT1 0 0 NCH L=1u W=8u
COP1_7 o1_7 0 0.1f
COM1_7 ob1_7 0 0.1f

* column pair cp1_8/cn1_8: 12 four-quadrant synapses + bias row
MVA1_0_8P cp1_8 g_VA1_0_8 bp 0 NCH L=1u W=4u
MVB1_0_8P cp1_8 g_VB1_0_8 bm 0 NCH L=1u W=4u
MVB1_0_8N cn1_8 g_VB1_0_8 bp 0 NCH L=1u W=4u
MVA1_0_8N cn1_8 g_VA1_0_8 bm 0 NCH L=1u W=4u
MVA1_1_8P cp1_8 g_VA1_1_8 o0_1 0 NCH L=1u W=4u
MVB1_1_8P cp1_8 g_VB1_1_8 ob0_1 0 NCH L=1u W=4u
MVB1_1_8N cn1_8 g_VB1_1_8 o0_1 0 NCH L=1u W=4u
MVA1_1_8N cn1_8 g_VA1_1_8 ob0_1 0 NCH L=1u W=4u
MVA1_2_8P cp1_8 g_VA1_2_8 o0_2 0 NCH L=1u W=4u
MVB1_2_8P cp1_8 g_VB1_2_8 ob0_2 0 NCH L=1u W=4u
MVB1_2_8N cn1_8 g_VB1_2_8 o0_2 0 NCH L=1u W=4u
MVA1_2_8N cn1_8 g_VA1_2_8 ob0_2 0 NCH L=1u W=4u
MVA1_3_8P cp1_8 g_VA1_3_8 o0_3 0 NCH L=1u W=4u
MVB1_3_8P cp1_8 g_VB1_3_8 ob0_3 0 NCH L=1u W=4u
MVB1_3_8N cn1_8 g_VB1_3_8 o0_3 0 NCH L=1u W=4u
MVA1_3_8N cn1_8 g_VA1_3_8 ob0_3 0 NCH L=1u W=4u
MVA1_4_8P cp1_8 g_VA1_4_8 o0_4 0 NCH L=1u W=4u
MVB1_4_8P cp1_8 g_VB1_4_8 ob0_4 0 NCH L=1u W=4u
MVB1_4_8N cn1_8 g_VB1_4_8 o0_4 0 NCH L=1u W=4u
MVA1_4_8N cn1_8 g_VA1_4_8 ob0_4 0 NCH L=1u W=4u
MVA1_5_8P cp1_8 g_VA1_5_8 o0_5 0 NCH L=1u W=4u
MVB1_5_8P cp1_8 g_VB1_5_8 ob0_5 0 NCH L=1u W=4u
MVB1_5_8N cn1_8 g_VB1_5_8 o0_5 0 NCH L=1u W=4u
MVA1_5_8N cn1_8 g_VA1_5_8 ob0_5 0 NCH L=1u W=4u
MVA1_6_8P cp1_8 g_VA1_6_8 o0_6 0 NCH L=1u W=4u
MVB1_6_8P cp1_8 g_VB1_6_8 ob0_6 0 NCH L=1u W=4u
MVB1_6_8N cn1_8 g_VB1_6_8 o0_6 0 NCH L=1u W=4u
MVA1_6_8N cn1_8 g_VA1_6_8 ob0_6 0 NCH L=1u W=4u
MVA1_7_8P cp1_8 g_VA1_7_8 o0_7 0 NCH L=1u W=4u
MVB1_7_8P cp1_8 g_VB1_7_8 ob0_7 0 NCH L=1u W=4u
MVB1_7_8N cn1_8 g_VB1_7_8 o0_7 0 NCH L=1u W=4u
MVA1_7_8N cn1_8 g_VA1_7_8 ob0_7 0 NCH L=1u W=4u
MVA1_8_8P cp1_8 g_VA1_8_8 o0_8 0 NCH L=1u W=4u
MVB1_8_8P cp1_8 g_VB1_8_8 ob0_8 0 NCH L=1u W=4u
MVB1_8_8N cn1_8 g_VB1_8_8 o0_8 0 NCH L=1u W=4u
MVA1_8_8N cn1_8 g_VA1_8_8 ob0_8 0 NCH L=1u W=4u
MVA1_9_8P cp1_8 g_VA1_9_8 o0_9 0 NCH L=1u W=4u
MVB1_9_8P cp1_8 g_VB1_9_8 ob0_9 0 NCH L=1u W=4u
MVB1_9_8N cn1_8 g_VB1_9_8 o0_9 0 NCH L=1u W=4u
MVA1_9_8N cn1_8 g_VA1_9_8 ob0_9 0 NCH L=1u W=4u
MVA1_10_8P cp1_8 g_VA1_10_8 o0_10 0 NCH L=1u W=4u
MVB1_10_8P cp1_8 g_VB1_10_8 ob0_10 0 NCH L=1u W=4u
MVB1_10_8N cn1_8 g_VB1_10_8 o0_10 0 NCH L=1u W=4u
MVA1_10_8N cn1_8 g_VA1_10_8 ob0_10 0 NCH L=1u W=4u
MVA1_11_8P cp1_8 g_VA1_11_8 o0_11 0 NCH L=1u W=4u
MVB1_11_8P cp1_8 g_VB1_11_8 ob0_11 0 NCH L=1u W=4u
MVB1_11_8N cn1_8 g_VB1_11_8 o0_11 0 NCH L=1u W=4u
MVA1_11_8N cn1_8 g_VA1_11_8 ob0_11 0 NCH L=1u W=4u
MVA1_12_8P cp1_8 g_VA1_12_8 o0_12 0 NCH L=1u W=4u
MVB1_12_8P cp1_8 g_VB1_12_8 ob0_12 0 NCH L=1u W=4u
MVB1_12_8N cn1_8 g_VB1_12_8 o0_12 0 NCH L=1u W=4u
MVA1_12_8N cn1_8 g_VA1_12_8 ob0_12 0 NCH L=1u W=4u
RLP1_8 vdd cp1_8 337
RLN1_8 vdd cn1_8 337
CCP1_8 cp1_8 0 0.1f
CCN1_8 cn1_8 0 0.1f
MDP1_8 ob1_8 cp1_8 t1_8 0 NCH L=1u W=8u
MDN1_8 o1_8 cn1_8 t1_8 0 NCH L=1u W=8u
RDP1_8 vdd ob1_8 10k
RDN1_8 vdd o1_8 10k
MT1_8 t1_8 g_VT1 0 0 NCH L=1u W=8u
COP1_8 o1_8 0 0.1f
COM1_8 ob1_8 0 0.1f

* column pair cp1_9/cn1_9: 12 four-quadrant synapses + bias row
MVA1_0_9P cp1_9 g_VA1_0_9 bp 0 NCH L=1u W=4u
MVB1_0_9P cp1_9 g_VB1_0_9 bm 0 NCH L=1u W=4u
MVB1_0_9N cn1_9 g_VB1_0_9 bp 0 NCH L=1u W=4u
MVA1_0_9N cn1_9 g_VA1_0_9 bm 0 NCH L=1u W=4u
MVA1_1_9P cp1_9 g_VA1_1_9 o0_1 0 NCH L=1u W=4u
MVB1_1_9P cp1_9 g_VB1_1_9 ob0_1 0 NCH L=1u W=4u
MVB1_1_9N cn1_9 g_VB1_1_9 o0_1 0 NCH L=1u W=4u
MVA1_1_9N cn1_9 g_VA1_1_9 ob0_1 0 NCH L=1u W=4u
MVA1_2_9P cp1_9 g_VA1_2_9 o0_2 0 NCH L=1u W=4u
MVB1_2_9P cp1_9 g_VB1_2_9 ob0_2 0 NCH L=1u W=4u
MVB1_2_9N cn1_9 g_VB1_2_9 o0_2 0 NCH L=1u W=4u
MVA1_2_9N cn1_9 g_VA1_2_9 ob0_2 0 NCH L=1u W=4u
MVA1_3_9P cp1_9 g_VA1_3_9 o0_3 0 NCH L=1u W=4u
MVB1_3_9P cp1_9 g_VB1_3_9 ob0_3 0 NCH L=1u W=4u
MVB1_3_9N cn1_9 g_VB1_3_9 o0_3 0 NCH L=1u W=4u
MVA1_3_9N cn1_9 g_VA1_3_9 ob0_3 0 NCH L=1u W=4u
MVA1_4_9P cp1_9 g_VA1_4_9 o0_4 0 NCH L=1u W=4u
MVB1_4_9P cp1_9 g_VB1_4_9 ob0_4 0 NCH L=1u W=4u
MVB1_4_9N cn1_9 g_VB1_4_9 o0_4 0 NCH L=1u W=4u
MVA1_4_9N cn1_9 g_VA1_4_9 ob0_4 0 NCH L=1u W=4u
MVA1_5_9P cp1_9 g_VA1_5_9 o0_5 0 NCH L=1u W=4u
MVB1_5_9P cp1_9 g_VB1_5_9 ob0_5 0 NCH L=1u W=4u
MVB1_5_9N cn1_9 g_VB1_5_9 o0_5 0 NCH L=1u W=4u
MVA1_5_9N cn1_9 g_VA1_5_9 ob0_5 0 NCH L=1u W=4u
MVA1_6_9P cp1_9 g_VA1_6_9 o0_6 0 NCH L=1u W=4u
MVB1_6_9P cp1_9 g_VB1_6_9 ob0_6 0 NCH L=1u W=4u
MVB1_6_9N cn1_9 g_VB1_6_9 o0_6 0 NCH L=1u W=4u
MVA1_6_9N cn1_9 g_VA1_6_9 ob0_6 0 NCH L=1u W=4u
MVA1_7_9P cp1_9 g_VA1_7_9 o0_7 0 NCH L=1u W=4u
MVB1_7_9P cp1_9 g_VB1_7_9 ob0_7 0 NCH L=1u W=4u
MVB1_7_9N cn1_9 g_VB1_7_9 o0_7 0 NCH L=1u W=4u
MVA1_7_9N cn1_9 g_VA1_7_9 ob0_7 0 NCH L=1u W=4u
MVA1_8_9P cp1_9 g_VA1_8_9 o0_8 0 NCH L=1u W=4u
MVB1_8_9P cp1_9 g_VB1_8_9 ob0_8 0 NCH L=1u W=4u
MVB1_8_9N cn1_9 g_VB1_8_9 o0_8 0 NCH L=1u W=4u
MVA1_8_9N cn1_9 g_VA1_8_9 ob0_8 0 NCH L=1u W=4u
MVA1_9_9P cp1_9 g_VA1_9_9 o0_9 0 NCH L=1u W=4u
MVB1_9_9P cp1_9 g_VB1_9_9 ob0_9 0 NCH L=1u W=4u
MVB1_9_9N cn1_9 g_VB1_9_9 o0_9 0 NCH L=1u W=4u
MVA1_9_9N cn1_9 g_VA1_9_9 ob0_9 0 NCH L=1u W=4u
MVA1_10_9P cp1_9 g_VA1_10_9 o0_10 0 NCH L=1u W=4u
MVB1_10_9P cp1_9 g_VB1_10_9 ob0_10 0 NCH L=1u W=4u
MVB1_10_9N cn1_9 g_VB1_10_9 o0_10 0 NCH L=1u W=4u
MVA1_10_9N cn1_9 g_VA1_10_9 ob0_10 0 NCH L=1u W=4u
MVA1_11_9P cp1_9 g_VA1_11_9 o0_11 0 NCH L=1u W=4u
MVB1_11_9P cp1_9 g_VB1_11_9 ob0_11 0 NCH L=1u W=4u
MVB1_11_9N cn1_9 g_VB1_11_9 o0_11 0 NCH L=1u W=4u
MVA1_11_9N cn1_9 g_VA1_11_9 ob0_11 0 NCH L=1u W=4u
MVA1_12_9P cp1_9 g_VA1_12_9 o0_12 0 NCH L=1u W=4u
MVB1_12_9P cp1_9 g_VB1_12_9 ob0_12 0 NCH L=1u W=4u
MVB1_12_9N cn1_9 g_VB1_12_9 o0_12 0 NCH L=1u W=4u
MVA1_12_9N cn1_9 g_VA1_12_9 ob0_12 0 NCH L=1u W=4u
RLP1_9 vdd cp1_9 337
RLN1_9 vdd cn1_9 337
CCP1_9 cp1_9 0 0.1f
CCN1_9 cn1_9 0 0.1f
MDP1_9 ob1_9 cp1_9 t1_9 0 NCH L=1u W=8u
MDN1_9 o1_9 cn1_9 t1_9 0 NCH L=1u W=8u
RDP1_9 vdd ob1_9 10k
RDN1_9 vdd o1_9 10k
MT1_9 t1_9 g_VT1 0 0 NCH L=1u W=8u
COP1_9 o1_9 0 0.1f
COM1_9 ob1_9 0 0.1f

* column pair cp1_10/cn1_10: 12 four-quadrant synapses + bias row
MVA1_0_10P cp1_10 g_VA1_0_10 bp 0 NCH L=1u W=4u
MVB1_0_10P cp1_10 g_VB1_0_10 bm 0 NCH L=1u W=4u
MVB1_0_10N cn1_10 g_VB1_0_10 bp 0 NCH L=1u W=4u
MVA1_0_10N cn1_10 g_VA1_0_10 bm 0 NCH L=1u W=4u
MVA1_1_10P cp1_10 g_VA1_1_10 o0_1 0 NCH L=1u W=4u
MVB1_1_10P cp1_10 g_VB1_1_10 ob0_1 0 NCH L=1u W=4u
MVB1_1_10N cn1_10 g_VB1_1_10 o0_1 0 NCH L=1u W=4u
MVA1_1_10N cn1_10 g_VA1_1_10 ob0_1 0 NCH L=1u W=4u
MVA1_2_10P cp1_10 g_VA1_2_10 o0_2 0 NCH L=1u W=4u
MVB1_2_10P cp1_10 g_VB1_2_10 ob0_2 0 NCH L=1u W=4u
MVB1_2_10N cn1_10 g_VB1_2_10 o0_2 0 NCH L=1u W=4u
MVA1_2_10N cn1_10 g_VA1_2_10 ob0_2 0 NCH L=1u W=4u
MVA1_3_10P cp1_10 g_VA1_3_10 o0_3 0 NCH L=1u W=4u
MVB1_3_10P cp1_10 g_VB1_3_10 ob0_3 0 NCH L=1u W=4u
MVB1_3_10N cn1_10 g_VB1_3_10 o0_3 0 NCH L=1u W=4u
MVA1_3_10N cn1_10 g_VA1_3_10 ob0_3 0 NCH L=1u W=4u
MVA1_4_10P cp1_10 g_VA1_4_10 o0_4 0 NCH L=1u W=4u
MVB1_4_10P cp1_10 g_VB1_4_10 ob0_4 0 NCH L=1u W=4u
MVB1_4_10N cn1_10 g_VB1_4_10 o0_4 0 NCH L=1u W=4u
MVA1_4_10N cn1_10 g_VA1_4_10 ob0_4 0 NCH L=1u W=4u
MVA1_5_10P cp1_10 g_VA1_5_10 o0_5 0 NCH L=1u W=4u
MVB1_5_10P cp1_10 g_VB1_5_10 ob0_5 0 NCH L=1u W=4u
MVB1_5_10N cn1_10 g_VB1_5_10 o0_5 0 NCH L=1u W=4u
MVA1_5_10N cn1_10 g_VA1_5_10 ob0_5 0 NCH L=1u W=4u
MVA1_6_10P cp1_10 g_VA1_6_10 o0_6 0 NCH L=1u W=4u
MVB1_6_10P cp1_10 g_VB1_6_10 ob0_6 0 NCH L=1u W=4u
MVB1_6_10N cn1_10 g_VB1_6_10 o0_6 0 NCH L=1u W=4u
MVA1_6_10N cn1_10 g_VA1_6_10 ob0_6 0 NCH L=1u W=4u
MVA1_7_10P cp1_10 g_VA1_7_10 o0_7 0 NCH L=1u W=4u
MVB1_7_10P cp1_10 g_VB1_7_10 ob0_7 0 NCH L=1u W=4u
MVB1_7_10N cn1_10 g_VB1_7_10 o0_7 0 NCH L=1u W=4u
MVA1_7_10N cn1_10 g_VA1_7_10 ob0_7 0 NCH L=1u W=4u
MVA1_8_10P cp1_10 g_VA1_8_10 o0_8 0 NCH L=1u W=4u
MVB1_8_10P cp1_10 g_VB1_8_10 ob0_8 0 NCH L=1u W=4u
MVB1_8_10N cn1_10 g_VB1_8_10 o0_8 0 NCH L=1u W=4u
MVA1_8_10N cn1_10 g_VA1_8_10 ob0_8 0 NCH L=1u W=4u
MVA1_9_10P cp1_10 g_VA1_9_10 o0_9 0 NCH L=1u W=4u
MVB1_9_10P cp1_10 g_VB1_9_10 ob0_9 0 NCH L=1u W=4u
MVB1_9_10N cn1_10 g_VB1_9_10 o0_9 0 NCH L=1u W=4u
MVA1_9_10N cn1_10 g_VA1_9_10 ob0_9 0 NCH L=1u W=4u
MVA1_10_10P cp1_10 g_VA1_10_10 o0_10 0 NCH L=1u W=4u
MVB1_10_10P cp1_10 g_VB1_10_10 ob0_10 0 NCH L=1u W=4u
MVB1_10_10N cn1_10 g_VB1_10_10 o0_10 0 NCH L=1u W=4u
MVA1_10_10N cn1_10 g_VA1_10_10 ob0_10 0 NCH L=1u W=4u
MVA1_11_10P cp1_10 g_VA1_11_10 o0_11 0 NCH L=1u W=4u
MVB1_11_10P cp1_10 g_VB1_11_10 ob0_11 0 NCH L=1u W=4u
MVB1_11_10N cn1_10 g_VB1_11_10 o0_11 0 NCH L=1u W=4u
MVA1_11_10N cn1_10 g_VA1_11_10 ob0_11 0 NCH L=1u W=4u
MVA1_12_10P cp1_10 g_VA1_12_10 o0_12 0 NCH L=1u W=4u
MVB1_12_10P cp1_10 g_VB1_12_10 ob0_12 0 NCH L=1u W=4u
MVB1_12_10N cn1_10 g_VB1_12_10 o0_12 0 NCH L=1u W=4u
MVA1_12_10N cn1_10 g_VA1_12_10 ob0_12 0 NCH L=1u W=4u
RLP1_10 vdd cp1_10 337
RLN1_10 vdd cn1_10 337
CCP1_10 cp1_10 0 0.1f
CCN1_10 cn1_10 0 0.1f
MDP1_10 ob1_10 cp1_10 t1_10 0 NCH L=1u W=8u
MDN1_10 o1_10 cn1_10 t1_10 0 NCH L=1u W=8u
RDP1_10 vdd ob1_10 10k
RDN1_10 vdd o1_10 10k
MT1_10 t1_10 g_VT1 0 0 NCH L=1u W=8u
COP1_10 o1_10 0 0.1f
COM1_10 ob1_10 0 0.1f

* neutral solver seed; the data is in the input sources
.IC V(cp0_1)=1.0000 V(cn0_1)=1.0000 V(o0_1)=1.0000 V(ob0_1)=1.0000 V(cp0_2)=1.0000 V(cn0_2)=1.0000 V(o0_2)=1.0000 V(ob0_2)=1.0000 V(cp0_3)=1.0000 V(cn0_3)=1.0000 V(o0_3)=1.0000 V(ob0_3)=1.0000 V(cp0_4)=1.0000 V(cn0_4)=1.0000 V(o0_4)=1.0000 V(ob0_4)=1.0000 V(cp0_5)=1.0000 V(cn0_5)=1.0000 V(o0_5)=1.0000 V(ob0_5)=1.0000 V(cp0_6)=1.0000 V(cn0_6)=1.0000 V(o0_6)=1.0000 V(ob0_6)=1.0000 V(cp0_7)=1.0000 V(cn0_7)=1.0000 V(o0_7)=1.0000 V(ob0_7)=1.0000 V(cp0_8)=1.0000 V(cn0_8)=1.0000 V(o0_8)=1.0000 V(ob0_8)=1.0000 V(cp0_9)=1.0000 V(cn0_9)=1.0000 V(o0_9)=1.0000 V(ob0_9)=1.0000 V(cp0_10)=1.0000 V(cn0_10)=1.0000 V(o0_10)=1.0000 V(ob0_10)=1.0000 V(cp0_11)=1.0000 V(cn0_11)=1.0000 V(o0_11)=1.0000 V(ob0_11)=1.0000 V(cp0_12)=1.0000 V(cn0_12)=1.0000 V(o0_12)=1.0000 V(ob0_12)=1.0000 V(cp1_1)=1.0000 V(cn1_1)=1.0000 V(o1_1)=1.0000 V(ob1_1)=1.0000 V(cp1_2)=1.0000 V(cn1_2)=1.0000 V(o1_2)=1.0000 V(ob1_2)=1.0000 V(cp1_3)=1.0000 V(cn1_3)=1.0000 V(o1_3)=1.0000 V(ob1_3)=1.0000 V(cp1_4)=1.0000 V(cn1_4)=1.0000 V(o1_4)=1.0000 V(ob1_4)=1.0000 V(cp1_5)=1.0000 V(cn1_5)=1.0000 V(o1_5)=1.0000 V(ob1_5)=1.0000 V(cp1_6)=1.0000 V(cn1_6)=1.0000 V(o1_6)=1.0000 V(ob1_6)=1.0000 V(cp1_7)=1.0000 V(cn1_7)=1.0000 V(o1_7)=1.0000 V(ob1_7)=1.0000 V(cp1_8)=1.0000 V(cn1_8)=1.0000 V(o1_8)=1.0000 V(ob1_8)=1.0000 V(cp1_9)=1.0000 V(cn1_9)=1.0000 V(o1_9)=1.0000 V(ob1_9)=1.0000 V(cp1_10)=1.0000 V(cn1_10)=1.0000 V(o1_10)=1.0000 V(ob1_10)=1.0000

.TRAN 50n 100n

.END
